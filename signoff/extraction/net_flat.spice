* SPICE netlist generated by Yosys 0.60+8 (git sha1 0e31e389f, g++ 13.1.0-8ubuntu1~22.04 -fPIC -O3)

.include "$PDK_ROOT/sky130A/libs.ref/sky130_fd_sc_hd/spice/sky130_fd_sc_hd.spice"

.global VGND VNB VPB VPWR

.subckt alu_32bit carry_o clk opcode[0] opcode[1] opcode[2] opcode[3] operand_a[0]
+ operand_a[10] operand_a[11] operand_a[12] operand_a[13] operand_a[14] operand_a[15]
+ operand_a[16] operand_a[17] operand_a[18] operand_a[19] operand_a[1] operand_a[20]
+ operand_a[21] operand_a[22] operand_a[23] operand_a[24] operand_a[25] operand_a[26]
+ operand_a[27] operand_a[28] operand_a[29] operand_a[2] operand_a[30] operand_a[31]
+ operand_a[3] operand_a[4] operand_a[5] operand_a[6] operand_a[7] operand_a[8] operand_a[9]
+ operand_b[0] operand_b[10] operand_b[11] operand_b[12] operand_b[13] operand_b[14]
+ operand_b[15] operand_b[16] operand_b[17] operand_b[18] operand_b[19] operand_b[1]
+ operand_b[20] operand_b[21] operand_b[22] operand_b[23] operand_b[24] operand_b[25]
+ operand_b[26] operand_b[27] operand_b[28] operand_b[29] operand_b[2] operand_b[30]
+ operand_b[31] operand_b[3] operand_b[4] operand_b[5] operand_b[6] operand_b[7] operand_b[8]
+ operand_b[9] overflow_o result_o[0] result_o[10] result_o[11] result_o[12] result_o[13]
+ result_o[14] result_o[15] result_o[16] result_o[17] result_o[18] result_o[19] result_o[1]
+ result_o[20] result_o[21] result_o[22] result_o[23] result_o[24] result_o[25] result_o[26]
+ result_o[27] result_o[28] result_o[29] result_o[2] result_o[30] result_o[31] result_o[3]
+ result_o[4] result_o[5] result_o[6] result_o[7] result_o[8] result_o[9] rst_n valid_i
+ valid_o zero_o

X0 _0039_ b_q_1_ sky130_fd_sc_hd__clkinv_1
X1 _0050_ a_q_5_ sky130_fd_sc_hd__clkinv_1
X2 _0060_ a_q_7_ sky130_fd_sc_hd__clkinv_1
X3 _0070_ b_q_2_ sky130_fd_sc_hd__clkinv_1
X4 _0081_ b_q_3_ sky130_fd_sc_hd__clkinv_1
X5 _0091_ a_q_27_ sky130_fd_sc_hd__clkinv_1
X6 _0102_ b_q_4_ sky130_fd_sc_hd__clkinv_1
X7 _0112_ b_q_25_ sky130_fd_sc_hd__clkinv_1
X8 _0123_ b_q_21_ sky130_fd_sc_hd__clkinv_1
X9 _0133_ a_q_31_ b_q_31_ sky130_fd_sc_hd__nand2_1
X10 _0143_ a_q_31_ b_q_31_ sky130_fd_sc_hd__nor2_1
X11 _0153_ _0143_ _0133_ sky130_fd_sc_hd__lpflow_isobufsrc_1
X12 _0163_ a_q_31_ _0153_ sky130_fd_sc_hd__nand2_1
X13 _0167_ b_q_30_ a_q_30_ sky130_fd_sc_hd__lpflow_isobufsrc_1
X14 _0168_ a_q_30_ b_q_30_ sky130_fd_sc_hd__nand2_1
X15 _0169_ a_q_30_ b_q_30_ sky130_fd_sc_hd__nor2_1
X16 _0170_ _0169_ _0168_ sky130_fd_sc_hd__lpflow_isobufsrc_1
X17 _0171_ b_q_29_ a_q_29_ sky130_fd_sc_hd__nand2b_1
X18 _0172_ a_q_29_ b_q_29_ sky130_fd_sc_hd__nand2_1
X19 _0173_ a_q_29_ b_q_29_ sky130_fd_sc_hd__nor2_1
X20 _0174_ _0173_ _0172_ sky130_fd_sc_hd__lpflow_isobufsrc_1
X21 _0175_ a_q_29_ b_q_29_ sky130_fd_sc_hd__xnor2_1
X22 _0176_ b_q_28_ a_q_28_ sky130_fd_sc_hd__nand2b_1
X23 _0177_ a_q_28_ b_q_28_ sky130_fd_sc_hd__nand2_1
X24 _0178_ a_q_28_ b_q_28_ sky130_fd_sc_hd__xor2_1
X25 _0179_ a_q_28_ b_q_28_ sky130_fd_sc_hd__xnor2_1
X26 _0180_ a_q_27_ b_q_27_ sky130_fd_sc_hd__nand2_1
X27 _0181_ a_q_27_ b_q_27_ sky130_fd_sc_hd__nor2_1
X28 _0182_ _0181_ _0180_ sky130_fd_sc_hd__lpflow_isobufsrc_1
X29 _0183_ a_q_27_ b_q_27_ sky130_fd_sc_hd__xnor2_1
X30 _0184_ a_q_26_ b_q_26_ sky130_fd_sc_hd__and2_0
X31 _0185_ a_q_26_ b_q_26_ sky130_fd_sc_hd__nor2_1
X32 _0186_ _0184_ _0185_ sky130_fd_sc_hd__nor2_1
X33 _0187_ _0184_ _0185_ sky130_fd_sc_hd__lpflow_inputiso1p_1
X34 _0188_ _0183_ _0187_ sky130_fd_sc_hd__nand2_1
X35 _0189_ a_q_25_ b_q_25_ sky130_fd_sc_hd__and2_0
X36 _0190_ a_q_25_ b_q_25_ sky130_fd_sc_hd__nor2_1
X37 _0191_ _0189_ _0190_ sky130_fd_sc_hd__nor2_1
X38 _0192_ _0189_ _0190_ sky130_fd_sc_hd__lpflow_inputiso1p_1
X39 _0193_ a_q_24_ b_q_24_ sky130_fd_sc_hd__nand2_1
X40 _0194_ a_q_24_ b_q_24_ sky130_fd_sc_hd__nor2_1
X41 _0195_ _0194_ _0193_ sky130_fd_sc_hd__lpflow_isobufsrc_1
X42 _0196_ a_q_24_ b_q_24_ sky130_fd_sc_hd__xnor2_1
X43 _0197_ b_q_23_ a_q_23_ sky130_fd_sc_hd__nand2b_1
X44 _0198_ a_q_23_ b_q_23_ sky130_fd_sc_hd__nand2_1
X45 _0199_ a_q_23_ b_q_23_ sky130_fd_sc_hd__xor2_1
X46 _0200_ b_q_22_ a_q_22_ sky130_fd_sc_hd__nand2b_1
X47 _0201_ _0199_ _0200_ _0197_ sky130_fd_sc_hd__o21ai_0
X48 _0202_ a_q_22_ b_q_22_ sky130_fd_sc_hd__nand2_1
X49 _0203_ a_q_22_ b_q_22_ sky130_fd_sc_hd__xor2_1
X50 _0204_ _0203_ sky130_fd_sc_hd__clkinv_1
X51 _0205_ a_q_21_ b_q_21_ sky130_fd_sc_hd__nand2_1
X52 _0206_ a_q_21_ b_q_21_ sky130_fd_sc_hd__xor2_1
X53 _0207_ a_q_21_ b_q_21_ sky130_fd_sc_hd__xnor2_1
X54 _0208_ a_q_20_ b_q_20_ sky130_fd_sc_hd__xnor2_1
X55 _0209_ a_q_19_ b_q_19_ sky130_fd_sc_hd__nor2_1
X56 _0210_ a_q_19_ b_q_19_ sky130_fd_sc_hd__nand2_1
X57 _0211_ _0209_ _0210_ sky130_fd_sc_hd__nand2b_1
X58 _0212_ a_q_18_ b_q_18_ sky130_fd_sc_hd__and2_0
X59 _0213_ a_q_18_ b_q_18_ sky130_fd_sc_hd__nor2_1
X60 _0214_ _0212_ _0213_ sky130_fd_sc_hd__nor2_1
X61 _0215_ _0212_ _0213_ sky130_fd_sc_hd__lpflow_inputiso1p_1
X62 _0216_ _0211_ _0215_ sky130_fd_sc_hd__nand2_1
X63 _0217_ a_q_17_ b_q_17_ sky130_fd_sc_hd__xor2_1
X64 _0218_ a_q_17_ b_q_17_ sky130_fd_sc_hd__xnor2_1
X65 _0219_ a_q_16_ b_q_16_ sky130_fd_sc_hd__nand2_1
X66 _0220_ a_q_16_ b_q_16_ sky130_fd_sc_hd__nor2_1
X67 _0221_ _0220_ _0219_ sky130_fd_sc_hd__lpflow_isobufsrc_1
X68 _0222_ a_q_16_ b_q_16_ sky130_fd_sc_hd__xnor2_1
X69 _0223_ b_q_15_ a_q_15_ sky130_fd_sc_hd__nand2b_1
X70 _0224_ a_q_15_ b_q_15_ sky130_fd_sc_hd__lpflow_inputiso1p_1
X71 _0225_ a_q_15_ b_q_15_ sky130_fd_sc_hd__nand2_1
X72 _0226_ _0224_ _0225_ sky130_fd_sc_hd__nand2_1
X73 _0227_ b_q_14_ a_q_14_ sky130_fd_sc_hd__lpflow_isobufsrc_1
X74 _0228_ a_q_14_ b_q_14_ sky130_fd_sc_hd__nand2_1
X75 _0229_ a_q_14_ b_q_14_ sky130_fd_sc_hd__xnor2_1
X76 _0230_ b_q_13_ a_q_13_ sky130_fd_sc_hd__lpflow_isobufsrc_1
X77 _0231_ a_q_13_ b_q_13_ sky130_fd_sc_hd__nand2_1
X78 _0232_ a_q_13_ b_q_13_ sky130_fd_sc_hd__xor2_1
X79 _0233_ a_q_13_ b_q_13_ sky130_fd_sc_hd__xnor2_1
X80 _0234_ b_q_12_ a_q_12_ sky130_fd_sc_hd__lpflow_isobufsrc_1
X81 _0235_ a_q_12_ b_q_12_ sky130_fd_sc_hd__nand2_1
X82 _0236_ a_q_12_ b_q_12_ sky130_fd_sc_hd__nor2_1
X83 _0237_ _0236_ _0235_ sky130_fd_sc_hd__lpflow_isobufsrc_1
X84 _0238_ b_q_11_ a_q_11_ sky130_fd_sc_hd__nand2b_1
X85 _0239_ a_q_11_ b_q_11_ sky130_fd_sc_hd__nor2_1
X86 _0240_ a_q_11_ b_q_11_ sky130_fd_sc_hd__and2_0
X87 _0241_ _0239_ _0240_ sky130_fd_sc_hd__lpflow_inputiso1p_1
X88 _0242_ b_q_10_ a_q_10_ sky130_fd_sc_hd__lpflow_isobufsrc_1
X89 _0243_ a_q_10_ b_q_10_ sky130_fd_sc_hd__nand2_1
X90 _0244_ a_q_10_ b_q_10_ sky130_fd_sc_hd__xnor2_1
X91 _0245_ b_q_9_ a_q_9_ sky130_fd_sc_hd__lpflow_isobufsrc_1
X92 _0246_ a_q_9_ b_q_9_ sky130_fd_sc_hd__nor2_1
X93 _0247_ a_q_9_ b_q_9_ sky130_fd_sc_hd__nand2_1
X94 _0248_ _0246_ _0247_ sky130_fd_sc_hd__nor2b_1
X95 _0249_ _0246_ _0247_ sky130_fd_sc_hd__nand2b_1
X96 _0250_ b_q_8_ a_q_8_ sky130_fd_sc_hd__nand2b_1
X97 _0251_ a_q_8_ b_q_8_ sky130_fd_sc_hd__nand2_1
X98 _0252_ a_q_8_ b_q_8_ sky130_fd_sc_hd__xnor2_1
X99 _0253_ _0060_ b_q_7_ sky130_fd_sc_hd__nor2_1
X100 _0254_ a_q_7_ b_q_7_ sky130_fd_sc_hd__nor2_1
X101 _0255_ a_q_7_ b_q_7_ sky130_fd_sc_hd__nand2_1
X102 _0256_ _0254_ _0255_ sky130_fd_sc_hd__nand2b_1
X103 _0257_ b_q_6_ a_q_6_ sky130_fd_sc_hd__lpflow_isobufsrc_1
X104 _0258_ a_q_6_ b_q_6_ sky130_fd_sc_hd__nand2_1
X105 _0259_ a_q_6_ b_q_6_ sky130_fd_sc_hd__xor2_1
X106 _0260_ b_q_5_ a_q_5_ sky130_fd_sc_hd__nand2b_1
X107 _0261_ a_q_5_ b_q_5_ sky130_fd_sc_hd__nor2_1
X108 _0262_ a_q_5_ b_q_5_ sky130_fd_sc_hd__and2_0
X109 _0263_ a_q_5_ b_q_5_ sky130_fd_sc_hd__nand2_1
X110 _0264_ _0261_ _0262_ sky130_fd_sc_hd__lpflow_inputiso1p_1
X111 _0265_ b_q_4_ a_q_4_ sky130_fd_sc_hd__lpflow_isobufsrc_1
X112 _0266_ a_q_4_ b_q_4_ sky130_fd_sc_hd__nand2_1
X113 _0267_ a_q_4_ b_q_4_ sky130_fd_sc_hd__lpflow_inputiso1p_1
X114 _0268_ _0266_ _0267_ sky130_fd_sc_hd__and2_0
X115 _0269_ _0268_ sky130_fd_sc_hd__clkinv_1
X116 _0270_ b_q_3_ a_q_3_ sky130_fd_sc_hd__lpflow_isobufsrc_1
X117 _0271_ a_q_3_ b_q_3_ sky130_fd_sc_hd__nand2b_1
X118 _0272_ a_q_2_ b_q_2_ sky130_fd_sc_hd__nand2_1
X119 _0273_ _0272_ sky130_fd_sc_hd__clkinv_1
X120 _0274_ a_q_2_ b_q_2_ sky130_fd_sc_hd__xnor2_1
X121 _0275_ a_q_0_ b_q_0_ sky130_fd_sc_hd__nand2b_1
X122 _0276_ a_q_1_ b_q_1_ sky130_fd_sc_hd__nor2_1
X123 _0277_ a_q_1_ b_q_1_ sky130_fd_sc_hd__nand2_1
X124 _0278_ a_q_1_ b_q_1_ sky130_fd_sc_hd__xor2_1
X125 _0279_ a_q_1_ _0039_ _0275_ sky130_fd_sc_hd__maj3_1
X126 _0280_ a_q_2_ _0070_ _0279_ sky130_fd_sc_hd__maj3_1
X127 _0281_ _0270_ _0280_ _0271_ sky130_fd_sc_hd__o21a_1
X128 _0282_ _0270_ _0280_ _0271_ _0269_ sky130_fd_sc_hd__o211a_1
X129 _0283_ _0265_ _0282_ _0264_ sky130_fd_sc_hd__o21ai_0
X130 _0284_ _0260_ _0283_ _0259_ sky130_fd_sc_hd__a21oi_1
X131 _0285_ _0257_ _0284_ _0256_ sky130_fd_sc_hd__o21a_1
X132 _0286_ _0253_ _0285_ _0252_ sky130_fd_sc_hd__o21ai_0
X133 _0287_ _0250_ _0286_ _0248_ sky130_fd_sc_hd__a21oi_1
X134 _0288_ _0245_ _0287_ _0244_ sky130_fd_sc_hd__o21a_1
X135 _0289_ _0242_ _0288_ _0241_ sky130_fd_sc_hd__o21ai_0
X136 _0290_ _0238_ _0289_ _0237_ sky130_fd_sc_hd__a21oi_1
X137 _0291_ _0234_ _0290_ _0233_ sky130_fd_sc_hd__o21a_1
X138 _0292_ _0230_ _0291_ _0229_ sky130_fd_sc_hd__o21a_1
X139 _0293_ _0227_ _0292_ _0226_ sky130_fd_sc_hd__o21ai_0
X140 _0294_ _0223_ _0293_ sky130_fd_sc_hd__nand2_1
X141 _0295_ _0222_ _0294_ sky130_fd_sc_hd__nand2_1
X142 _0296_ _0223_ _0293_ _0217_ _0221_ sky130_fd_sc_hd__a211o_1
X143 _0297_ _0223_ _0293_ _0216_ _0217_ _0221_ sky130_fd_sc_hd__a2111oi_0
X144 _0298_ b_q_17_ a_q_17_ sky130_fd_sc_hd__lpflow_isobufsrc_1
X145 _0299_ b_q_16_ a_q_16_ sky130_fd_sc_hd__lpflow_isobufsrc_1
X146 _0300_ _0218_ _0299_ _0298_ sky130_fd_sc_hd__a21oi_1
X147 _0301_ _0216_ _0300_ sky130_fd_sc_hd__nor2_1
X148 _0302_ b_q_19_ a_q_19_ sky130_fd_sc_hd__lpflow_isobufsrc_1
X149 _0303_ b_q_18_ a_q_18_ sky130_fd_sc_hd__lpflow_isobufsrc_1
X150 _0304_ _0211_ _0303_ _0302_ _0301_ sky130_fd_sc_hd__a211oi_1
X151 _0305_ _0304_ sky130_fd_sc_hd__clkinv_1
X152 _0306_ _0297_ _0305_ _0208_ sky130_fd_sc_hd__o21ai_0
X153 _0307_ _0297_ _0305_ _0207_ _0208_ sky130_fd_sc_hd__o211ai_1
X154 _0308_ b_q_20_ a_q_20_ sky130_fd_sc_hd__nand2b_1
X155 _0309_ _0206_ _0308_ sky130_fd_sc_hd__nor2_1
X156 _0310_ a_q_21_ _0123_ _0309_ sky130_fd_sc_hd__a21oi_1
X157 _0311_ _0307_ _0310_ sky130_fd_sc_hd__nand2_1
X158 _0312_ _0307_ _0310_ _0199_ _0203_ sky130_fd_sc_hd__a211oi_1
X159 _0313_ _0199_ _0203_ sky130_fd_sc_hd__nor2_1
X160 _0314_ _0201_ _0313_ sky130_fd_sc_hd__nor2_1
X161 _0315_ _0201_ _0310_ sky130_fd_sc_hd__nor2b_1
X162 _0316_ _0201_ _0312_ _0196_ sky130_fd_sc_hd__o21ai_0
X163 _0317_ _0307_ _0315_ _0314_ _0191_ _0195_ sky130_fd_sc_hd__a2111o_1
X164 _0318_ b_q_24_ a_q_24_ sky130_fd_sc_hd__nand2b_1
X165 _0319_ _0191_ _0318_ sky130_fd_sc_hd__nor2_1
X166 _0320_ a_q_25_ _0112_ _0319_ sky130_fd_sc_hd__a21oi_1
X167 _0321_ b_q_26_ a_q_26_ sky130_fd_sc_hd__lpflow_isobufsrc_1
X168 _0322_ _0091_ b_q_27_ _0188_ _0320_ sky130_fd_sc_hd__o22ai_1
X169 _0323_ _0183_ _0321_ _0322_ sky130_fd_sc_hd__a21oi_1
X170 _0324_ _0182_ _0186_ _0317_ _0323_ sky130_fd_sc_hd__o31a_1
X171 _0325_ _0178_ _0324_ sky130_fd_sc_hd__lpflow_inputiso1p_1
X172 _0326_ _0178_ _0324_ _0176_ sky130_fd_sc_hd__o21ai_0
X173 _0327_ _0175_ _0326_ sky130_fd_sc_hd__nand2_1
X174 _0328_ _0175_ _0326_ _0171_ sky130_fd_sc_hd__a21boi_0
X175 _0329_ _0170_ _0328_ sky130_fd_sc_hd__nor2_1
X176 _0330_ _0170_ _0328_ _0167_ sky130_fd_sc_hd__o21bai_1
X177 _0331_ _0153_ _0330_ _0163_ sky130_fd_sc_hd__o21ai_0
X178 _0332_ opcode_q_2_ opcode_q_3_ sky130_fd_sc_hd__nor2_1
X179 _0333_ opcode_q_0_ opcode_q_1_ sky130_fd_sc_hd__lpflow_isobufsrc_1
X180 _0334_ opcode_q_3_ opcode_q_2_ sky130_fd_sc_hd__lpflow_isobufsrc_1
X181 _0335_ opcode_q_0_ _0334_ sky130_fd_sc_hd__nand2_1
X182 _0336_ opcode_q_0_ opcode_q_1_ _0334_ sky130_fd_sc_hd__nand3_1
X183 _0337_ _0336_ sky130_fd_sc_hd__clkinv_1
X184 _0338_ opcode_q_0_ opcode_q_1_ sky130_fd_sc_hd__nor2_1
X185 _0339_ opcode_q_2_ opcode_q_3_ _0338_ sky130_fd_sc_hd__nand3b_1
X186 _0340_ _0336_ _0339_ sky130_fd_sc_hd__nand2_1
X187 _0341_ _0336_ _0339_ b_q_4_ sky130_fd_sc_hd__a21oi_1
X188 _0342_ _0102_ _0340_ sky130_fd_sc_hd__nand2_1
X189 _0343_ a_q_4_ a_q_5_ b_q_0_ sky130_fd_sc_hd__mux2i_1
X190 _0344_ b_q_0_ a_q_6_ sky130_fd_sc_hd__nand2b_1
X191 _0345_ b_q_0_ a_q_7_ sky130_fd_sc_hd__nand2_1
X192 _0346_ b_q_1_ _0344_ _0345_ sky130_fd_sc_hd__and3_1
X193 _0347_ _0039_ _0343_ _0346_ sky130_fd_sc_hd__a21oi_1
X194 _0348_ b_q_0_ a_q_2_ sky130_fd_sc_hd__lpflow_isobufsrc_1
X195 _0349_ b_q_0_ a_q_3_ _0348_ sky130_fd_sc_hd__a21oi_1
X196 _0350_ b_q_0_ a_q_0_ sky130_fd_sc_hd__lpflow_isobufsrc_1
X197 _0351_ _0039_ _0350_ sky130_fd_sc_hd__nand2_1
X198 _0352_ a_q_1_ b_q_0_ b_q_1_ _0350_ sky130_fd_sc_hd__a211oi_1
X199 _0353_ b_q_1_ _0349_ _0352_ b_q_2_ sky130_fd_sc_hd__a211oi_1
X200 _0354_ b_q_0_ a_q_8_ sky130_fd_sc_hd__nand2b_1
X201 _0355_ b_q_0_ a_q_9_ sky130_fd_sc_hd__nand2_1
X202 _0356_ _0354_ _0355_ sky130_fd_sc_hd__nand2_1
X203 _0357_ b_q_0_ a_q_10_ sky130_fd_sc_hd__lpflow_isobufsrc_1
X204 _0358_ b_q_0_ a_q_11_ sky130_fd_sc_hd__nand2_1
X205 _0359_ b_q_0_ a_q_11_ _0357_ sky130_fd_sc_hd__a21oi_1
X206 _0360_ b_q_1_ _0359_ sky130_fd_sc_hd__nand2_1
X207 _0361_ b_q_1_ _0356_ _0360_ sky130_fd_sc_hd__o21ai_0
X208 _0362_ b_q_2_ _0361_ sky130_fd_sc_hd__nor2_1
X209 _0363_ b_q_0_ a_q_12_ sky130_fd_sc_hd__nand2b_1
X210 _0364_ b_q_0_ a_q_13_ sky130_fd_sc_hd__nand2_1
X211 _0365_ _0363_ _0364_ sky130_fd_sc_hd__nand2_1
X212 _0366_ b_q_0_ a_q_14_ sky130_fd_sc_hd__lpflow_isobufsrc_1
X213 _0367_ b_q_0_ a_q_15_ sky130_fd_sc_hd__nand2_1
X214 _0368_ b_q_0_ a_q_15_ _0366_ sky130_fd_sc_hd__a21oi_1
X215 _0369_ b_q_1_ _0365_ sky130_fd_sc_hd__nor2_1
X216 _0370_ b_q_1_ _0368_ _0369_ sky130_fd_sc_hd__a21oi_1
X217 _0371_ b_q_2_ _0370_ _0362_ sky130_fd_sc_hd__a21oi_1
X218 _0372_ b_q_2_ _0347_ _0353_ b_q_3_ sky130_fd_sc_hd__a211oi_1
X219 _0373_ b_q_3_ _0371_ _0372_ _0342_ sky130_fd_sc_hd__a211oi_1
X220 _0374_ b_q_4_ _0340_ sky130_fd_sc_hd__nand2_1
X221 _0375_ b_q_0_ a_q_16_ sky130_fd_sc_hd__nand2b_1
X222 _0376_ b_q_0_ a_q_17_ sky130_fd_sc_hd__nand2_1
X223 _0377_ _0375_ _0376_ sky130_fd_sc_hd__nand2_1
X224 _0378_ b_q_0_ a_q_18_ sky130_fd_sc_hd__lpflow_isobufsrc_1
X225 _0379_ b_q_0_ a_q_19_ _0378_ sky130_fd_sc_hd__a21oi_1
X226 _0380_ b_q_1_ _0379_ sky130_fd_sc_hd__nand2_1
X227 _0381_ b_q_1_ _0377_ _0380_ sky130_fd_sc_hd__o21ai_0
X228 _0382_ b_q_0_ a_q_20_ sky130_fd_sc_hd__lpflow_isobufsrc_1
X229 _0383_ b_q_0_ a_q_21_ sky130_fd_sc_hd__nand2_1
X230 _0384_ b_q_0_ a_q_21_ _0382_ sky130_fd_sc_hd__a21oi_1
X231 _0385_ b_q_1_ _0384_ sky130_fd_sc_hd__nor2_1
X232 _0386_ b_q_0_ a_q_22_ sky130_fd_sc_hd__nand2b_1
X233 _0387_ b_q_0_ a_q_23_ sky130_fd_sc_hd__nand2_1
X234 _0388_ _0386_ _0387_ sky130_fd_sc_hd__nand2_1
X235 _0389_ b_q_1_ _0388_ _0385_ sky130_fd_sc_hd__a21oi_1
X236 _0390_ _0381_ _0389_ b_q_2_ sky130_fd_sc_hd__mux2i_1
X237 _0391_ b_q_0_ a_q_24_ sky130_fd_sc_hd__lpflow_isobufsrc_1
X238 _0392_ b_q_0_ a_q_25_ _0391_ sky130_fd_sc_hd__a21oi_1
X239 _0393_ b_q_0_ a_q_26_ sky130_fd_sc_hd__lpflow_isobufsrc_1
X240 _0394_ b_q_0_ a_q_27_ sky130_fd_sc_hd__nand2_1
X241 _0395_ b_q_0_ a_q_27_ _0393_ sky130_fd_sc_hd__a21oi_1
X242 _0396_ _0392_ _0395_ b_q_1_ sky130_fd_sc_hd__mux2i_1
X243 _0397_ b_q_0_ a_q_28_ sky130_fd_sc_hd__nand2b_1
X244 _0398_ b_q_0_ a_q_29_ sky130_fd_sc_hd__nand2_1
X245 _0399_ _0397_ _0398_ sky130_fd_sc_hd__nand2_1
X246 _0400_ b_q_0_ a_q_30_ sky130_fd_sc_hd__lpflow_isobufsrc_1
X247 _0401_ b_q_0_ a_q_31_ _0400_ sky130_fd_sc_hd__a21oi_1
X248 _0402_ b_q_1_ _0401_ sky130_fd_sc_hd__nand2_1
X249 _0403_ b_q_1_ _0399_ _0402_ sky130_fd_sc_hd__o21ai_0
X250 _0404_ b_q_2_ _0403_ sky130_fd_sc_hd__nand2_1
X251 _0405_ b_q_2_ _0396_ _0404_ sky130_fd_sc_hd__o21ai_0
X252 _0406_ b_q_3_ _0405_ sky130_fd_sc_hd__nand2_1
X253 _0407_ b_q_3_ _0390_ _0406_ sky130_fd_sc_hd__o21ai_0
X254 _0408_ a_q_0_ b_q_0_ sky130_fd_sc_hd__nor2_1
X255 _0409_ _0334_ _0338_ sky130_fd_sc_hd__and2_0
X256 _0410_ _0334_ _0338_ sky130_fd_sc_hd__nand2_1
X257 _0411_ a_q_0_ b_q_0_ sky130_fd_sc_hd__nand2_1
X258 _0412_ opcode_q_1_ _0335_ sky130_fd_sc_hd__nor2_1
X259 _0413_ opcode_q_1_ _0335_ sky130_fd_sc_hd__lpflow_inputiso1p_1
X260 _0414_ opcode_q_1_ opcode_q_2_ opcode_q_3_ _0413_ sky130_fd_sc_hd__o31ai_1
X261 _0415_ _0411_ _0414_ _0409_ sky130_fd_sc_hd__a21oi_1
X262 _0416_ opcode_q_0_ _0332_ sky130_fd_sc_hd__nand2_1
X263 _0417_ opcode_q_0_ opcode_q_1_ _0332_ sky130_fd_sc_hd__and3_1
X264 _0418_ opcode_q_0_ opcode_q_1_ _0332_ sky130_fd_sc_hd__nand3_1
X265 _0419_ b_q_2_ b_q_3_ _0351_ sky130_fd_sc_hd__nor3_1
X266 _0420_ _0333_ _0334_ sky130_fd_sc_hd__and2_0
X267 _0421_ _0333_ _0334_ sky130_fd_sc_hd__nand2_1
X268 _0422_ b_q_4_ _0421_ sky130_fd_sc_hd__nor2_1
X269 _0423_ _0102_ _0420_ sky130_fd_sc_hd__nand2_1
X270 _0424_ _0408_ _0415_ _0418_ _0411_ sky130_fd_sc_hd__o22ai_1
X271 _0425_ _0419_ _0422_ _0424_ sky130_fd_sc_hd__a21oi_1
X272 _0426_ _0374_ _0407_ _0425_ sky130_fd_sc_hd__o21ai_0
X273 result_comb_0_ _0331_ _0332_ _0333_ _0373_ _0426_ sky130_fd_sc_hd__a311o_1
X274 _0427_ b_q_0_ a_q_17_ sky130_fd_sc_hd__nand2b_1
X275 _0428_ b_q_0_ a_q_18_ sky130_fd_sc_hd__nand2_1
X276 _0429_ _0427_ _0428_ sky130_fd_sc_hd__nand2_1
X277 _0430_ b_q_0_ a_q_19_ sky130_fd_sc_hd__lpflow_isobufsrc_1
X278 _0431_ b_q_0_ a_q_20_ _0430_ sky130_fd_sc_hd__a21oi_1
X279 _0432_ b_q_1_ _0429_ sky130_fd_sc_hd__nor2_1
X280 _0433_ b_q_1_ _0431_ _0432_ sky130_fd_sc_hd__a21oi_1
X281 _0434_ b_q_0_ a_q_22_ sky130_fd_sc_hd__nand2_1
X282 _0435_ a_q_21_ a_q_22_ b_q_0_ sky130_fd_sc_hd__mux2i_1
X283 _0436_ b_q_0_ a_q_23_ sky130_fd_sc_hd__nand2b_1
X284 _0437_ b_q_0_ a_q_24_ sky130_fd_sc_hd__nand2_1
X285 _0438_ _0436_ _0437_ sky130_fd_sc_hd__nand2_1
X286 _0439_ b_q_1_ _0438_ sky130_fd_sc_hd__nand2_1
X287 _0440_ b_q_1_ _0435_ _0439_ sky130_fd_sc_hd__o21ai_0
X288 _0441_ _0433_ _0440_ b_q_2_ sky130_fd_sc_hd__mux2i_1
X289 _0442_ b_q_3_ _0441_ sky130_fd_sc_hd__nor2_1
X290 _0443_ b_q_0_ a_q_25_ sky130_fd_sc_hd__lpflow_isobufsrc_1
X291 _0444_ b_q_0_ a_q_26_ _0443_ sky130_fd_sc_hd__a21oi_1
X292 _0445_ b_q_1_ _0444_ sky130_fd_sc_hd__nor2_1
X293 _0446_ a_q_27_ a_q_28_ b_q_0_ sky130_fd_sc_hd__mux2_1
X294 _0447_ b_q_1_ _0446_ _0445_ sky130_fd_sc_hd__a21oi_1
X295 _0448_ b_q_0_ a_q_29_ sky130_fd_sc_hd__lpflow_isobufsrc_1
X296 _0449_ b_q_0_ a_q_30_ _0448_ sky130_fd_sc_hd__a21oi_1
X297 _0450_ b_q_1_ _0449_ sky130_fd_sc_hd__nor2_1
X298 _0451_ b_q_0_ a_q_31_ sky130_fd_sc_hd__lpflow_isobufsrc_1
X299 _0452_ b_q_1_ _0451_ _0450_ sky130_fd_sc_hd__a21oi_1
X300 _0453_ _0447_ _0452_ b_q_2_ sky130_fd_sc_hd__mux2i_1
X301 _0454_ b_q_3_ _0453_ _0442_ sky130_fd_sc_hd__a21oi_1
X302 _0455_ b_q_1_ a_q_31_ _0450_ sky130_fd_sc_hd__a21oi_1
X303 _0456_ _0447_ _0455_ b_q_2_ sky130_fd_sc_hd__mux2i_1
X304 _0457_ b_q_3_ _0456_ _0442_ sky130_fd_sc_hd__a21oi_1
X305 _0458_ _0336_ _0454_ _0457_ _0339_ sky130_fd_sc_hd__o22ai_1
X306 _0459_ _0458_ sky130_fd_sc_hd__clkinv_1
X307 _0460_ b_q_0_ a_q_6_ sky130_fd_sc_hd__nand2_1
X308 _0461_ b_q_0_ _0050_ _0460_ sky130_fd_sc_hd__o21ai_0
X309 _0462_ b_q_0_ a_q_8_ sky130_fd_sc_hd__nand2_1
X310 _0463_ b_q_0_ _0060_ _0462_ sky130_fd_sc_hd__o21a_1
X311 _0464_ _0039_ _0463_ sky130_fd_sc_hd__nor2_1
X312 _0465_ _0039_ _0461_ _0464_ sky130_fd_sc_hd__a21oi_1
X313 _0466_ b_q_0_ a_q_1_ sky130_fd_sc_hd__lpflow_isobufsrc_1
X314 _0467_ a_q_3_ a_q_4_ b_q_0_ sky130_fd_sc_hd__mux2i_1
X315 _0468_ b_q_0_ a_q_2_ b_q_1_ _0466_ sky130_fd_sc_hd__a211oi_1
X316 _0469_ b_q_1_ _0467_ _0468_ b_q_2_ sky130_fd_sc_hd__a211oi_1
X317 _0470_ _0070_ _0465_ _0081_ sky130_fd_sc_hd__o21ai_0
X318 _0471_ b_q_0_ a_q_9_ sky130_fd_sc_hd__nand2b_1
X319 _0472_ b_q_0_ a_q_10_ sky130_fd_sc_hd__nand2_1
X320 _0473_ _0471_ _0472_ sky130_fd_sc_hd__nand2_1
X321 _0474_ b_q_0_ a_q_11_ sky130_fd_sc_hd__lpflow_isobufsrc_1
X322 _0475_ b_q_0_ a_q_12_ sky130_fd_sc_hd__nand2_1
X323 _0476_ b_q_0_ a_q_12_ _0474_ sky130_fd_sc_hd__a21oi_1
X324 _0477_ b_q_1_ _0476_ sky130_fd_sc_hd__nand2_1
X325 _0478_ b_q_1_ _0473_ _0477_ sky130_fd_sc_hd__o21ai_0
X326 _0479_ b_q_2_ _0478_ sky130_fd_sc_hd__nor2_1
X327 _0480_ b_q_0_ a_q_13_ sky130_fd_sc_hd__nand2b_1
X328 _0481_ b_q_0_ a_q_14_ sky130_fd_sc_hd__nand2_1
X329 _0482_ _0480_ _0481_ sky130_fd_sc_hd__nand2_1
X330 _0483_ b_q_0_ a_q_15_ sky130_fd_sc_hd__lpflow_isobufsrc_1
X331 _0484_ b_q_0_ a_q_16_ sky130_fd_sc_hd__nand2_1
X332 _0485_ b_q_0_ a_q_16_ _0483_ sky130_fd_sc_hd__a21oi_1
X333 _0486_ b_q_1_ _0482_ sky130_fd_sc_hd__nor2_1
X334 _0487_ b_q_1_ _0485_ _0486_ sky130_fd_sc_hd__a21oi_1
X335 _0488_ b_q_2_ _0487_ _0479_ sky130_fd_sc_hd__a21oi_1
X336 _0489_ b_q_3_ _0488_ _0342_ sky130_fd_sc_hd__a21oi_1
X337 _0490_ _0469_ _0470_ _0489_ sky130_fd_sc_hd__o21ai_0
X338 _0491_ a_q_0_ b_q_0_ _0466_ sky130_fd_sc_hd__a21oi_1
X339 _0492_ b_q_1_ _0491_ sky130_fd_sc_hd__lpflow_inputiso1p_1
X340 _0493_ b_q_2_ _0492_ sky130_fd_sc_hd__nor2_1
X341 _0494_ _0081_ _0422_ _0493_ sky130_fd_sc_hd__nand3_1
X342 _0495_ a_q_0_ b_q_0_ _0278_ sky130_fd_sc_hd__a21oi_1
X343 _0496_ opcode_q_0_ opcode_q_1_ opcode_q_2_ opcode_q_3_ sky130_fd_sc_hd__nor4_1
X344 _0497_ _0332_ _0338_ sky130_fd_sc_hd__nand2_1
X345 _0498_ a_q_0_ b_q_0_ _0278_ sky130_fd_sc_hd__nand3_1
X346 _0499_ _0496_ _0498_ sky130_fd_sc_hd__nand2_1
X347 _0500_ opcode_q_1_ _0416_ sky130_fd_sc_hd__nor2_1
X348 _0501_ opcode_q_1_ _0416_ sky130_fd_sc_hd__lpflow_inputiso1p_1
X349 _0502_ _0275_ _0278_ sky130_fd_sc_hd__xnor2_1
X350 _0503_ _0500_ _0502_ sky130_fd_sc_hd__nand2_1
X351 _0504_ _0495_ _0499_ _0503_ sky130_fd_sc_hd__o21ai_0
X352 _0505_ _0277_ _0412_ _0409_ sky130_fd_sc_hd__a21oi_1
X353 _0506_ _0277_ _0418_ _0505_ _0276_ sky130_fd_sc_hd__o22ai_1
X354 _0507_ _0504_ _0506_ sky130_fd_sc_hd__nor2_1
X355 result_comb_1_ _0102_ _0459_ _0490_ _0494_ _0507_ sky130_fd_sc_hd__o2111ai_1
X356 _0508_ _0379_ _0384_ b_q_1_ sky130_fd_sc_hd__mux2_1
X357 _0509_ b_q_2_ _0508_ sky130_fd_sc_hd__nor2_1
X358 _0510_ b_q_1_ _0388_ sky130_fd_sc_hd__nor2_1
X359 _0511_ b_q_1_ _0392_ _0510_ sky130_fd_sc_hd__a21oi_1
X360 _0512_ b_q_2_ _0511_ _0509_ sky130_fd_sc_hd__a21oi_1
X361 _0513_ b_q_3_ _0512_ sky130_fd_sc_hd__nor2_1
X362 _0514_ b_q_1_ _0401_ sky130_fd_sc_hd__lpflow_inputiso1p_1
X363 _0515_ b_q_1_ _0399_ sky130_fd_sc_hd__nand2_1
X364 _0516_ b_q_1_ _0395_ _0515_ sky130_fd_sc_hd__o21ai_0
X365 _0517_ b_q_2_ _0516_ sky130_fd_sc_hd__nor2_1
X366 _0518_ b_q_2_ _0514_ _0517_ sky130_fd_sc_hd__a21oi_1
X367 _0519_ b_q_3_ _0518_ _0513_ sky130_fd_sc_hd__a21oi_1
X368 _0520_ b_q_1_ b_q_2_ a_q_31_ _0518_ sky130_fd_sc_hd__a31o_1
X369 _0521_ b_q_3_ _0520_ _0513_ sky130_fd_sc_hd__a21oi_1
X370 _0522_ _0336_ _0519_ _0521_ _0339_ sky130_fd_sc_hd__o22ai_1
X371 _0523_ b_q_4_ _0522_ sky130_fd_sc_hd__nand2_1
X372 _0524_ _0344_ _0345_ b_q_1_ sky130_fd_sc_hd__a21oi_1
X373 _0525_ b_q_1_ _0356_ _0524_ sky130_fd_sc_hd__a21oi_1
X374 _0526_ _0039_ _0343_ _0070_ sky130_fd_sc_hd__o21a_1
X375 _0527_ b_q_1_ _0349_ _0526_ sky130_fd_sc_hd__o21ai_0
X376 _0528_ b_q_2_ _0525_ sky130_fd_sc_hd__nand2_1
X377 _0529_ b_q_1_ _0365_ sky130_fd_sc_hd__nand2_1
X378 _0530_ b_q_1_ _0359_ _0529_ sky130_fd_sc_hd__o21ai_0
X379 _0531_ b_q_1_ _0368_ sky130_fd_sc_hd__nor2_1
X380 _0532_ b_q_1_ _0377_ _0531_ sky130_fd_sc_hd__a21oi_1
X381 _0533_ b_q_2_ _0532_ sky130_fd_sc_hd__nand2_1
X382 _0534_ b_q_2_ _0530_ _0533_ sky130_fd_sc_hd__o21ai_0
X383 _0535_ _0534_ sky130_fd_sc_hd__clkinv_1
X384 _0536_ _0081_ _0535_ sky130_fd_sc_hd__nor2_1
X385 _0537_ _0527_ _0528_ b_q_3_ sky130_fd_sc_hd__a21oi_1
X386 _0538_ a_q_1_ b_q_0_ _0348_ sky130_fd_sc_hd__a21oi_1
X387 _0539_ b_q_1_ _0538_ sky130_fd_sc_hd__nor2_1
X388 _0540_ b_q_1_ _0350_ _0539_ sky130_fd_sc_hd__a21o_1
X389 _0541_ _0070_ _0540_ sky130_fd_sc_hd__nand2_1
X390 _0542_ b_q_3_ _0423_ _0541_ sky130_fd_sc_hd__nor3_1
X391 _0543_ a_q_2_ b_q_2_ _0409_ sky130_fd_sc_hd__o21ai_0
X392 _0544_ _0274_ _0413_ _0418_ _0272_ _0543_ sky130_fd_sc_hd__o221ai_1
X393 _0545_ _0274_ _0279_ sky130_fd_sc_hd__xnor2_1
X394 _0546_ _0274_ _0277_ _0498_ sky130_fd_sc_hd__nand3_1
X395 _0547_ _0277_ _0498_ _0274_ sky130_fd_sc_hd__a21oi_1
X396 _0548_ _0496_ _0546_ sky130_fd_sc_hd__nand2_1
X397 _0549_ _0501_ _0545_ _0547_ _0548_ sky130_fd_sc_hd__o22ai_1
X398 _0550_ _0542_ _0544_ _0549_ sky130_fd_sc_hd__nor3_1
X399 result_comb_2_ _0342_ _0536_ _0537_ _0550_ _0523_ sky130_fd_sc_hd__o311ai_0
X400 _0551_ _0431_ _0435_ b_q_1_ sky130_fd_sc_hd__mux2_1
X401 _0552_ b_q_2_ _0551_ sky130_fd_sc_hd__nor2_1
X402 _0553_ b_q_1_ _0438_ sky130_fd_sc_hd__nor2_1
X403 _0554_ b_q_1_ _0444_ _0553_ sky130_fd_sc_hd__a21oi_1
X404 _0555_ b_q_2_ _0554_ _0552_ sky130_fd_sc_hd__a21oi_1
X405 _0556_ b_q_3_ _0555_ sky130_fd_sc_hd__nor2_1
X406 _0557_ b_q_1_ _0449_ sky130_fd_sc_hd__nand2_1
X407 _0558_ b_q_1_ _0446_ _0557_ sky130_fd_sc_hd__o21ai_0
X408 _0559_ _0039_ b_q_2_ _0451_ sky130_fd_sc_hd__nand3_1
X409 _0560_ b_q_2_ _0558_ _0559_ sky130_fd_sc_hd__o21ai_0
X410 _0561_ b_q_3_ _0560_ _0556_ sky130_fd_sc_hd__a21oi_1
X411 _0562_ b_q_2_ a_q_31_ sky130_fd_sc_hd__nand2_1
X412 _0563_ b_q_2_ _0558_ _0562_ sky130_fd_sc_hd__o21ai_0
X413 _0564_ b_q_3_ _0563_ _0556_ sky130_fd_sc_hd__a21oi_1
X414 _0565_ _0336_ _0561_ _0564_ _0339_ sky130_fd_sc_hd__o22a_1
X415 _0566_ _0039_ _0467_ sky130_fd_sc_hd__nand2_1
X416 _0567_ _0039_ _0461_ _0566_ _0070_ sky130_fd_sc_hd__o211ai_1
X417 _0568_ b_q_1_ _0463_ sky130_fd_sc_hd__nor2_1
X418 _0569_ b_q_1_ _0473_ _0568_ sky130_fd_sc_hd__a21oi_1
X419 _0570_ _0070_ _0569_ _0567_ sky130_fd_sc_hd__o21ai_0
X420 _0571_ b_q_1_ _0476_ sky130_fd_sc_hd__nor2_1
X421 _0572_ b_q_1_ _0482_ _0571_ sky130_fd_sc_hd__a21oi_1
X422 _0573_ b_q_2_ _0572_ sky130_fd_sc_hd__nor2_1
X423 _0574_ b_q_1_ _0429_ sky130_fd_sc_hd__nand2_1
X424 _0575_ b_q_1_ _0485_ _0574_ sky130_fd_sc_hd__o21ai_0
X425 _0576_ b_q_2_ _0575_ _0573_ sky130_fd_sc_hd__a21oi_1
X426 _0577_ b_q_3_ _0570_ _0341_ sky130_fd_sc_hd__o21ai_0
X427 _0578_ b_q_3_ _0576_ _0577_ sky130_fd_sc_hd__a21oi_1
X428 _0579_ a_q_3_ a_q_2_ b_q_0_ sky130_fd_sc_hd__mux2_1
X429 _0580_ _0039_ _0491_ sky130_fd_sc_hd__nor2_1
X430 _0581_ _0039_ _0579_ _0580_ sky130_fd_sc_hd__a21oi_1
X431 _0582_ b_q_2_ _0581_ sky130_fd_sc_hd__lpflow_inputiso1p_1
X432 _0583_ a_q_3_ b_q_3_ sky130_fd_sc_hd__nand2_1
X433 _0584_ _0583_ sky130_fd_sc_hd__clkinv_1
X434 _0585_ a_q_3_ b_q_3_ sky130_fd_sc_hd__lpflow_inputiso1p_1
X435 _0586_ _0583_ _0585_ sky130_fd_sc_hd__nand2_1
X436 _0587_ _0413_ _0586_ sky130_fd_sc_hd__nor2_1
X437 _0588_ _0417_ _0584_ _0585_ _0409_ _0587_ sky130_fd_sc_hd__a221oi_1
X438 _0589_ b_q_3_ _0423_ _0582_ _0588_ sky130_fd_sc_hd__o31ai_1
X439 _0590_ _0273_ _0547_ sky130_fd_sc_hd__nor2_1
X440 _0591_ _0586_ _0590_ sky130_fd_sc_hd__xor2_1
X441 _0592_ _0280_ _0586_ _0500_ sky130_fd_sc_hd__o21ai_0
X442 _0593_ _0280_ _0586_ _0592_ sky130_fd_sc_hd__a21oi_1
X443 _0594_ _0578_ _0593_ sky130_fd_sc_hd__nor2_1
X444 _0595_ _0102_ _0565_ _0594_ sky130_fd_sc_hd__o21ai_0
X445 result_comb_3_ _0496_ _0591_ _0595_ _0589_ sky130_fd_sc_hd__a211o_1
X446 _0596_ b_q_2_ _0389_ sky130_fd_sc_hd__nor2_1
X447 _0597_ b_q_2_ _0396_ _0596_ sky130_fd_sc_hd__a21oi_1
X448 _0598_ b_q_3_ _0597_ sky130_fd_sc_hd__nor2_1
X449 _0599_ b_q_2_ _0403_ sky130_fd_sc_hd__nor2_1
X450 _0600_ b_q_3_ _0599_ _0598_ sky130_fd_sc_hd__a21oi_1
X451 _0601_ b_q_2_ _0403_ _0562_ sky130_fd_sc_hd__o21ai_0
X452 _0602_ b_q_3_ _0601_ _0598_ sky130_fd_sc_hd__a21oi_1
X453 _0603_ _0336_ _0600_ _0602_ _0339_ sky130_fd_sc_hd__o22ai_1
X454 _0604_ b_q_4_ _0603_ sky130_fd_sc_hd__nand2_1
X455 _0605_ b_q_2_ _0381_ sky130_fd_sc_hd__nand2_1
X456 _0606_ b_q_2_ _0370_ _0605_ sky130_fd_sc_hd__o21ai_0
X457 _0607_ b_q_2_ _0347_ sky130_fd_sc_hd__nor2_1
X458 _0608_ b_q_2_ _0361_ _0607_ sky130_fd_sc_hd__a21oi_1
X459 _0609_ b_q_3_ _0608_ _0341_ sky130_fd_sc_hd__o21ai_0
X460 _0610_ b_q_3_ _0606_ _0609_ sky130_fd_sc_hd__a21oi_1
X461 _0611_ _0266_ _0418_ _0410_ sky130_fd_sc_hd__o21ai_0
X462 _0612_ _0268_ _0412_ _0611_ _0267_ sky130_fd_sc_hd__a22oi_1
X463 _0613_ a_q_4_ a_q_3_ b_q_0_ sky130_fd_sc_hd__mux2_1
X464 _0614_ b_q_1_ _0613_ sky130_fd_sc_hd__nor2_1
X465 _0615_ b_q_1_ _0538_ _0614_ sky130_fd_sc_hd__a21oi_1
X466 _0616_ b_q_2_ _0615_ sky130_fd_sc_hd__nor2_1
X467 _0617_ b_q_2_ _0351_ _0616_ sky130_fd_sc_hd__a21oi_1
X468 _0618_ _0282_ _0501_ sky130_fd_sc_hd__nor2_1
X469 _0619_ _0269_ _0281_ _0618_ sky130_fd_sc_hd__o21ai_0
X470 _0620_ _0583_ _0590_ sky130_fd_sc_hd__nand2_1
X471 _0621_ _0273_ _0547_ _0584_ _0585_ _0268_ sky130_fd_sc_hd__o311ai_0
X472 _0622_ _0585_ _0620_ _0268_ sky130_fd_sc_hd__a21oi_1
X473 _0623_ _0496_ _0621_ sky130_fd_sc_hd__nand2_1
X474 _0624_ _0081_ _0420_ _0617_ sky130_fd_sc_hd__and3_1
X475 _0625_ _0102_ _0624_ _0610_ sky130_fd_sc_hd__a21oi_1
X476 _0626_ _0622_ _0623_ _0625_ sky130_fd_sc_hd__o21a_1
X477 result_comb_4_ _0604_ _0612_ _0619_ _0626_ sky130_fd_sc_hd__nand4_1
X478 _0627_ _0264_ _0265_ _0282_ sky130_fd_sc_hd__nor3_1
X479 _0628_ _0283_ _0500_ sky130_fd_sc_hd__nand2_1
X480 _0629_ _0266_ _0621_ _0264_ sky130_fd_sc_hd__a21oi_1
X481 _0630_ _0266_ _0621_ _0264_ sky130_fd_sc_hd__a21o_1
X482 _0631_ _0264_ _0266_ _0621_ sky130_fd_sc_hd__nand3_1
X483 _0632_ _0496_ _0630_ _0631_ sky130_fd_sc_hd__nand3_1
X484 _0633_ b_q_2_ _0447_ sky130_fd_sc_hd__nand2_1
X485 _0634_ b_q_2_ _0440_ _0633_ sky130_fd_sc_hd__o21ai_0
X486 _0635_ b_q_3_ _0634_ sky130_fd_sc_hd__nor2_1
X487 _0636_ b_q_2_ _0452_ sky130_fd_sc_hd__nor2_1
X488 _0637_ b_q_3_ _0636_ _0635_ sky130_fd_sc_hd__a21oi_1
X489 _0638_ b_q_1_ b_q_2_ a_q_31_ sky130_fd_sc_hd__o21ai_0
X490 _0639_ b_q_2_ _0455_ _0562_ sky130_fd_sc_hd__o21ai_0
X491 _0640_ b_q_3_ _0639_ _0635_ sky130_fd_sc_hd__a21oi_1
X492 _0641_ _0336_ _0637_ _0640_ _0339_ sky130_fd_sc_hd__o22ai_1
X493 _0642_ _0433_ _0487_ _0070_ sky130_fd_sc_hd__mux2i_1
X494 _0643_ _0465_ _0478_ b_q_2_ sky130_fd_sc_hd__mux2i_1
X495 _0644_ b_q_3_ _0643_ _0341_ sky130_fd_sc_hd__o21ai_0
X496 _0645_ b_q_3_ _0642_ _0644_ sky130_fd_sc_hd__a21oi_1
X497 _0646_ a_q_5_ a_q_4_ b_q_0_ sky130_fd_sc_hd__mux2i_1
X498 _0647_ b_q_1_ _0579_ sky130_fd_sc_hd__nand2_1
X499 _0648_ b_q_1_ _0646_ _0647_ sky130_fd_sc_hd__o21ai_0
X500 _0649_ b_q_2_ _0492_ sky130_fd_sc_hd__nand2_1
X501 _0650_ b_q_2_ _0648_ _0649_ sky130_fd_sc_hd__o21ai_0
X502 _0651_ _0261_ _0410_ _0413_ _0264_ sky130_fd_sc_hd__o22ai_1
X503 _0652_ _0262_ _0417_ _0651_ sky130_fd_sc_hd__a21oi_1
X504 _0653_ b_q_3_ _0423_ _0650_ _0652_ sky130_fd_sc_hd__o31ai_1
X505 _0654_ b_q_4_ _0641_ _0645_ _0653_ sky130_fd_sc_hd__a211oi_1
X506 result_comb_5_ _0627_ _0628_ _0632_ _0654_ sky130_fd_sc_hd__o211ai_1
X507 _0655_ _0259_ _0260_ _0283_ sky130_fd_sc_hd__and3_1
X508 _0656_ _0284_ _0501_ _0655_ sky130_fd_sc_hd__nor3_1
X509 _0657_ _0262_ _0629_ _0259_ sky130_fd_sc_hd__o21ai_0
X510 _0658_ _0259_ _0263_ _0630_ sky130_fd_sc_hd__nand3b_1
X511 _0659_ _0657_ _0658_ sky130_fd_sc_hd__nand2_1
X512 _0660_ _0511_ _0516_ b_q_2_ sky130_fd_sc_hd__mux2i_1
X513 _0661_ b_q_3_ _0660_ sky130_fd_sc_hd__nor2_1
X514 _0662_ b_q_2_ _0514_ sky130_fd_sc_hd__nor2_1
X515 _0663_ b_q_3_ _0662_ _0661_ sky130_fd_sc_hd__a21oi_1
X516 _0664_ b_q_2_ _0514_ _0638_ sky130_fd_sc_hd__o21ai_0
X517 _0665_ b_q_3_ _0664_ _0661_ sky130_fd_sc_hd__a21oi_1
X518 _0666_ _0336_ _0663_ _0665_ _0339_ sky130_fd_sc_hd__o22ai_1
X519 _0667_ b_q_2_ _0525_ sky130_fd_sc_hd__nor2_1
X520 _0668_ b_q_2_ _0530_ _0667_ sky130_fd_sc_hd__a21oi_1
X521 _0669_ b_q_3_ _0668_ sky130_fd_sc_hd__nor2_1
X522 _0670_ _0508_ _0532_ _0070_ sky130_fd_sc_hd__mux2i_1
X523 _0671_ b_q_3_ _0670_ _0669_ sky130_fd_sc_hd__a21oi_1
X524 _0672_ _0259_ _0412_ sky130_fd_sc_hd__nand2_1
X525 _0673_ a_q_6_ b_q_6_ _0409_ sky130_fd_sc_hd__o21ai_0
X526 _0674_ _0258_ _0418_ _0672_ _0673_ sky130_fd_sc_hd__o211ai_1
X527 _0675_ b_q_0_ a_q_5_ _0344_ sky130_fd_sc_hd__a21boi_0
X528 _0676_ b_q_1_ _0613_ sky130_fd_sc_hd__nand2_1
X529 _0677_ b_q_1_ _0675_ _0676_ sky130_fd_sc_hd__o21ai_0
X530 _0678_ _0540_ _0677_ _0070_ sky130_fd_sc_hd__mux2i_1
X531 _0679_ b_q_3_ _0678_ sky130_fd_sc_hd__lpflow_inputiso1p_1
X532 _0680_ _0342_ _0671_ _0679_ _0423_ sky130_fd_sc_hd__o22ai_1
X533 _0681_ b_q_4_ _0666_ _0674_ _0680_ _0656_ sky130_fd_sc_hd__a2111oi_0
X534 result_comb_6_ _0497_ _0659_ _0681_ sky130_fd_sc_hd__o21ai_0
X535 _0682_ _0256_ _0257_ _0284_ sky130_fd_sc_hd__nor3_1
X536 _0683_ _0285_ _0501_ _0682_ sky130_fd_sc_hd__nor3_1
X537 _0684_ _0258_ _0657_ _0256_ sky130_fd_sc_hd__a21o_1
X538 _0685_ _0256_ _0258_ _0657_ _0497_ sky130_fd_sc_hd__a31oi_1
X539 _0686_ _0569_ _0572_ b_q_2_ sky130_fd_sc_hd__mux2i_1
X540 _0687_ b_q_2_ _0551_ sky130_fd_sc_hd__nand2_1
X541 _0688_ b_q_2_ _0575_ _0687_ sky130_fd_sc_hd__o21ai_0
X542 _0689_ b_q_3_ _0686_ sky130_fd_sc_hd__nor2_1
X543 _0690_ b_q_3_ _0688_ _0689_ _0342_ sky130_fd_sc_hd__a211oi_1
X544 _0691_ b_q_2_ _0558_ sky130_fd_sc_hd__nand2_1
X545 _0692_ b_q_2_ _0554_ _0691_ sky130_fd_sc_hd__o21ai_0
X546 _0693_ b_q_3_ _0339_ sky130_fd_sc_hd__nor2_1
X547 _0694_ b_q_3_ _0336_ sky130_fd_sc_hd__nor2_1
X548 _0695_ _0693_ _0694_ sky130_fd_sc_hd__nor2_1
X549 _0696_ _0339_ a_q_31_ sky130_fd_sc_hd__lpflow_isobufsrc_1
X550 _0697_ b_q_3_ _0696_ sky130_fd_sc_hd__and2_0
X551 _0698_ b_q_3_ _0696_ sky130_fd_sc_hd__nand2_1
X552 _0699_ _0039_ _0070_ _0451_ sky130_fd_sc_hd__and3_1
X553 _0700_ b_q_3_ _0337_ _0699_ _0697_ sky130_fd_sc_hd__a31oi_1
X554 _0701_ _0692_ _0695_ _0700_ sky130_fd_sc_hd__o21ai_0
X555 _0702_ b_q_0_ _0060_ _0460_ sky130_fd_sc_hd__o21ai_0
X556 _0703_ b_q_1_ _0702_ sky130_fd_sc_hd__nor2_1
X557 _0704_ b_q_1_ _0646_ _0703_ sky130_fd_sc_hd__a21oi_1
X558 _0705_ b_q_2_ _0581_ sky130_fd_sc_hd__nand2_1
X559 _0706_ b_q_2_ _0704_ _0705_ sky130_fd_sc_hd__o21ai_0
X560 _0707_ b_q_3_ _0423_ _0706_ sky130_fd_sc_hd__nor3_1
X561 _0708_ _0254_ _0410_ _0413_ _0256_ sky130_fd_sc_hd__o22ai_1
X562 _0709_ b_q_4_ _0701_ _0707_ _0708_ _0690_ sky130_fd_sc_hd__a2111oi_0
X563 _0710_ _0255_ _0418_ _0709_ sky130_fd_sc_hd__o21ai_0
X564 result_comb_7_ _0684_ _0685_ _0710_ _0683_ sky130_fd_sc_hd__a211o_1
X565 _0711_ _0252_ _0253_ _0285_ sky130_fd_sc_hd__nor3_1
X566 _0712_ _0286_ _0500_ sky130_fd_sc_hd__nand2_1
X567 _0713_ _0252_ _0255_ _0684_ sky130_fd_sc_hd__nand3_1
X568 _0714_ _0255_ _0684_ _0252_ sky130_fd_sc_hd__a21o_1
X569 _0715_ _0496_ _0713_ _0714_ sky130_fd_sc_hd__nand3_1
X570 _0716_ _0345_ _0354_ sky130_fd_sc_hd__nand2_1
X571 _0717_ b_q_1_ _0675_ sky130_fd_sc_hd__nand2_1
X572 _0718_ b_q_1_ _0716_ _0717_ sky130_fd_sc_hd__o21ai_0
X573 _0719_ b_q_2_ _0615_ sky130_fd_sc_hd__nand2_1
X574 _0720_ b_q_2_ _0718_ _0719_ sky130_fd_sc_hd__o21ai_0
X575 _0721_ b_q_2_ _0351_ b_q_3_ sky130_fd_sc_hd__o21ai_0
X576 _0722_ b_q_3_ _0720_ _0721_ _0420_ sky130_fd_sc_hd__o211ai_1
X577 _0723_ b_q_3_ _0390_ sky130_fd_sc_hd__nand2_1
X578 _0724_ b_q_3_ _0371_ _0723_ sky130_fd_sc_hd__o21ai_0
X579 _0725_ _0340_ _0724_ sky130_fd_sc_hd__nand2_1
X580 _0726_ _0722_ _0725_ b_q_4_ sky130_fd_sc_hd__a21oi_1
X581 _0727_ b_q_3_ _0405_ _0698_ sky130_fd_sc_hd__o21ai_0
X582 _0728_ _0374_ _0727_ sky130_fd_sc_hd__lpflow_isobufsrc_1
X583 _0729_ a_q_8_ b_q_8_ _0409_ sky130_fd_sc_hd__o21ai_0
X584 _0730_ _0252_ _0413_ _0418_ _0251_ _0729_ sky130_fd_sc_hd__o221ai_1
X585 _0731_ _0726_ _0728_ _0730_ sky130_fd_sc_hd__nor3_1
X586 result_comb_8_ _0711_ _0712_ _0715_ _0731_ sky130_fd_sc_hd__o211ai_1
X587 _0732_ _0248_ _0250_ _0286_ sky130_fd_sc_hd__nand3_1
X588 _0733_ _0287_ _0501_ sky130_fd_sc_hd__nor2_1
X589 _0734_ _0732_ _0733_ sky130_fd_sc_hd__nand2_1
X590 _0735_ _0249_ _0251_ _0714_ sky130_fd_sc_hd__nand3_1
X591 _0736_ _0255_ _0684_ _0249_ _0252_ sky130_fd_sc_hd__a211o_1
X592 _0737_ a_q_8_ b_q_8_ _0248_ sky130_fd_sc_hd__nand3_1
X593 _0738_ _0496_ _0735_ _0736_ _0737_ sky130_fd_sc_hd__nand4_1
X594 _0739_ _0456_ _0693_ _0694_ _0453_ _0697_ sky130_fd_sc_hd__a221o_1
X595 _0740_ b_q_3_ _0441_ sky130_fd_sc_hd__nand2_1
X596 _0741_ _0081_ _0488_ _0342_ sky130_fd_sc_hd__a21oi_1
X597 _0742_ _0247_ _0418_ sky130_fd_sc_hd__nor2_1
X598 _0743_ _0246_ _0410_ _0413_ _0249_ sky130_fd_sc_hd__o22ai_1
X599 _0744_ _0740_ _0741_ _0742_ _0743_ sky130_fd_sc_hd__a211oi_1
X600 _0745_ _0462_ _0471_ sky130_fd_sc_hd__nand2_1
X601 _0746_ _0702_ _0745_ _0039_ sky130_fd_sc_hd__mux2_1
X602 _0747_ _0648_ _0746_ _0070_ sky130_fd_sc_hd__mux2i_1
X603 _0748_ b_q_3_ _0493_ sky130_fd_sc_hd__nand2_1
X604 _0749_ b_q_3_ _0747_ _0748_ sky130_fd_sc_hd__o21ai_0
X605 _0750_ b_q_4_ _0739_ _0749_ _0422_ sky130_fd_sc_hd__a22oi_1
X606 result_comb_9_ _0734_ _0738_ _0744_ _0750_ sky130_fd_sc_hd__nand4_1
X607 _0751_ _0244_ _0245_ _0287_ sky130_fd_sc_hd__nor3_1
X608 _0752_ _0288_ _0501_ _0751_ sky130_fd_sc_hd__nor3_1
X609 _0753_ _0244_ _0247_ _0736_ _0737_ sky130_fd_sc_hd__nand4_1
X610 _0754_ _0247_ _0736_ _0737_ _0244_ sky130_fd_sc_hd__a31oi_1
X611 _0755_ _0497_ _0754_ sky130_fd_sc_hd__nor2_1
X612 _0756_ _0518_ _0694_ sky130_fd_sc_hd__nand2_1
X613 _0757_ _0520_ _0693_ _0697_ sky130_fd_sc_hd__a21oi_1
X614 _0758_ _0756_ _0757_ sky130_fd_sc_hd__nand2_1
X615 _0759_ b_q_0_ a_q_9_ _0357_ sky130_fd_sc_hd__a21oi_1
X616 _0760_ b_q_1_ _0759_ sky130_fd_sc_hd__nor2_1
X617 _0761_ b_q_1_ _0716_ _0760_ sky130_fd_sc_hd__a21oi_1
X618 _0762_ b_q_2_ _0761_ sky130_fd_sc_hd__nor2_1
X619 _0763_ b_q_2_ _0677_ _0762_ sky130_fd_sc_hd__a21oi_1
X620 _0764_ _0070_ _0540_ _0081_ sky130_fd_sc_hd__a21oi_1
X621 _0765_ _0081_ _0763_ _0764_ sky130_fd_sc_hd__a21oi_1
X622 _0766_ b_q_3_ _0512_ _0342_ sky130_fd_sc_hd__a21oi_1
X623 _0767_ b_q_3_ _0535_ _0766_ sky130_fd_sc_hd__o21ai_0
X624 _0768_ a_q_10_ b_q_10_ _0409_ sky130_fd_sc_hd__o21ai_0
X625 _0769_ _0244_ _0413_ _0418_ _0243_ _0768_ sky130_fd_sc_hd__o221ai_1
X626 _0770_ b_q_4_ _0758_ _0765_ _0422_ _0769_ sky130_fd_sc_hd__a221oi_1
X627 _0771_ _0767_ _0770_ sky130_fd_sc_hd__nand2_1
X628 result_comb_10_ _0753_ _0755_ _0771_ _0752_ sky130_fd_sc_hd__a211o_1
X629 _0772_ _0241_ _0242_ _0288_ sky130_fd_sc_hd__nor3_1
X630 _0773_ _0289_ _0500_ sky130_fd_sc_hd__nand2_1
X631 _0774_ _0241_ _0243_ sky130_fd_sc_hd__nand2_1
X632 _0775_ _0754_ _0774_ sky130_fd_sc_hd__nor2_1
X633 _0776_ _0247_ _0736_ _0737_ _0244_ _0241_ sky130_fd_sc_hd__a311oi_1
X634 _0777_ _0241_ _0243_ sky130_fd_sc_hd__nor2_1
X635 _0778_ _0497_ _0775_ _0776_ _0777_ sky130_fd_sc_hd__nor4_1
X636 _0779_ _0563_ _0693_ sky130_fd_sc_hd__nand2_1
X637 _0780_ _0560_ _0694_ sky130_fd_sc_hd__nand2_1
X638 _0781_ _0698_ _0779_ _0780_ _0102_ sky130_fd_sc_hd__a31oi_1
X639 _0782_ _0081_ _0576_ _0342_ sky130_fd_sc_hd__a21o_1
X640 _0783_ b_q_3_ _0555_ _0782_ sky130_fd_sc_hd__a21oi_1
X641 _0784_ b_q_0_ a_q_10_ _0474_ sky130_fd_sc_hd__a21oi_1
X642 _0785_ b_q_1_ _0784_ sky130_fd_sc_hd__nor2_1
X643 _0786_ b_q_1_ _0745_ _0785_ sky130_fd_sc_hd__a21oi_1
X644 _0787_ b_q_2_ _0786_ sky130_fd_sc_hd__nor2_1
X645 _0788_ b_q_2_ _0704_ _0787_ sky130_fd_sc_hd__a21oi_1
X646 _0789_ _0582_ _0788_ _0081_ sky130_fd_sc_hd__mux2i_1
X647 _0790_ _0239_ _0410_ _0413_ _0241_ sky130_fd_sc_hd__o22ai_1
X648 _0791_ _0240_ _0417_ _0422_ _0789_ _0790_ sky130_fd_sc_hd__a221o_1
X649 _0792_ _0778_ _0781_ _0783_ _0791_ sky130_fd_sc_hd__nor4_1
X650 result_comb_11_ _0772_ _0773_ _0792_ sky130_fd_sc_hd__o21ai_0
X651 _0793_ _0237_ _0238_ _0289_ sky130_fd_sc_hd__and3_1
X652 _0794_ _0290_ _0501_ _0793_ sky130_fd_sc_hd__nor3_1
X653 _0795_ _0240_ _0776_ _0777_ _0237_ sky130_fd_sc_hd__o31ai_1
X654 _0796_ _0237_ _0240_ _0776_ _0777_ sky130_fd_sc_hd__nor4_1
X655 _0797_ _0496_ _0795_ sky130_fd_sc_hd__nand2_1
X656 _0798_ _0601_ _0693_ _0694_ _0599_ _0697_ sky130_fd_sc_hd__a221o_1
X657 _0799_ b_q_4_ _0798_ sky130_fd_sc_hd__nand2_1
X658 _0800_ _0235_ _0412_ _0409_ sky130_fd_sc_hd__a21oi_1
X659 _0801_ _0081_ _0606_ _0342_ sky130_fd_sc_hd__a21o_1
X660 _0802_ b_q_3_ _0597_ _0801_ sky130_fd_sc_hd__a21oi_1
X661 _0803_ _0358_ _0363_ sky130_fd_sc_hd__nand2_1
X662 _0804_ b_q_1_ _0803_ sky130_fd_sc_hd__nor2_1
X663 _0805_ b_q_1_ _0759_ _0804_ sky130_fd_sc_hd__a21oi_1
X664 _0806_ b_q_2_ _0718_ sky130_fd_sc_hd__nand2_1
X665 _0807_ b_q_2_ _0805_ _0806_ sky130_fd_sc_hd__o21ai_0
X666 _0808_ b_q_3_ _0807_ sky130_fd_sc_hd__nor2_1
X667 _0809_ b_q_3_ _0617_ _0808_ sky130_fd_sc_hd__a21oi_1
X668 _0810_ _0236_ _0800_ _0799_ sky130_fd_sc_hd__o21ai_0
X669 _0811_ _0235_ _0418_ _0423_ _0809_ sky130_fd_sc_hd__o22ai_1
X670 _0812_ _0794_ _0802_ _0810_ _0811_ sky130_fd_sc_hd__nor4_1
X671 result_comb_12_ _0796_ _0797_ _0812_ sky130_fd_sc_hd__o21ai_0
X672 _0813_ _0233_ _0234_ _0290_ sky130_fd_sc_hd__nor3_1
X673 _0814_ _0291_ _0501_ _0813_ sky130_fd_sc_hd__or3_1
X674 _0815_ _0233_ _0235_ _0795_ sky130_fd_sc_hd__nand3_1
X675 _0816_ _0240_ _0776_ _0777_ _0237_ _0232_ sky130_fd_sc_hd__o311ai_0
X676 _0817_ _0233_ _0235_ _0496_ _0815_ _0816_ sky130_fd_sc_hd__o2111ai_1
X677 _0818_ _0475_ _0480_ sky130_fd_sc_hd__nand2_1
X678 _0819_ b_q_1_ _0784_ sky130_fd_sc_hd__nand2_1
X679 _0820_ b_q_1_ _0818_ _0819_ sky130_fd_sc_hd__o21ai_0
X680 _0821_ b_q_2_ _0820_ sky130_fd_sc_hd__nor2_1
X681 _0822_ b_q_2_ _0746_ _0821_ sky130_fd_sc_hd__a21oi_1
X682 _0823_ _0650_ _0822_ _0081_ sky130_fd_sc_hd__mux2_1
X683 _0824_ a_q_13_ b_q_13_ _0409_ sky130_fd_sc_hd__o21ai_0
X684 _0825_ _0233_ _0413_ _0418_ _0231_ _0824_ sky130_fd_sc_hd__o221ai_1
X685 _0826_ b_q_3_ _0634_ sky130_fd_sc_hd__nand2_1
X686 _0827_ _0081_ _0642_ _0342_ sky130_fd_sc_hd__a21oi_1
X687 _0828_ _0636_ _0694_ sky130_fd_sc_hd__nand2_1
X688 _0829_ _0639_ _0693_ _0697_ sky130_fd_sc_hd__a21oi_1
X689 _0830_ _0828_ _0829_ sky130_fd_sc_hd__nand2_1
X690 _0831_ _0826_ _0827_ _0825_ sky130_fd_sc_hd__a21oi_1
X691 _0832_ _0423_ _0823_ _0831_ sky130_fd_sc_hd__o21ai_0
X692 _0833_ b_q_4_ _0830_ _0832_ sky130_fd_sc_hd__a21oi_1
X693 result_comb_13_ _0814_ _0817_ _0833_ sky130_fd_sc_hd__nand3_1
X694 _0834_ _0229_ _0230_ _0291_ sky130_fd_sc_hd__nor3_1
X695 _0835_ _0233_ _0235_ _0231_ sky130_fd_sc_hd__o21a_1
X696 _0836_ _0816_ _0835_ _0229_ sky130_fd_sc_hd__a21o_1
X697 _0837_ _0229_ _0816_ _0835_ _0497_ sky130_fd_sc_hd__a31oi_1
X698 _0838_ b_q_0_ a_q_13_ _0366_ sky130_fd_sc_hd__a21oi_1
X699 _0839_ b_q_1_ _0803_ sky130_fd_sc_hd__nand2_1
X700 _0840_ b_q_1_ _0838_ _0839_ sky130_fd_sc_hd__o21ai_0
X701 _0841_ b_q_2_ _0840_ sky130_fd_sc_hd__nor2_1
X702 _0842_ b_q_2_ _0761_ _0841_ sky130_fd_sc_hd__a21oi_1
X703 _0843_ b_q_3_ _0842_ _0420_ sky130_fd_sc_hd__o21ai_0
X704 _0844_ b_q_3_ _0678_ _0843_ sky130_fd_sc_hd__a21oi_1
X705 _0845_ b_q_3_ _0670_ _0340_ sky130_fd_sc_hd__o21ai_0
X706 _0846_ b_q_3_ _0660_ _0845_ sky130_fd_sc_hd__a21oi_1
X707 _0847_ _0844_ _0846_ _0102_ sky130_fd_sc_hd__o21ai_0
X708 _0848_ _0662_ _0694_ sky130_fd_sc_hd__nand2_1
X709 _0849_ _0664_ _0693_ _0697_ sky130_fd_sc_hd__a21oi_1
X710 _0850_ _0848_ _0849_ sky130_fd_sc_hd__nand2_1
X711 _0851_ b_q_4_ _0850_ sky130_fd_sc_hd__nand2_1
X712 _0852_ a_q_14_ b_q_14_ _0413_ sky130_fd_sc_hd__a21oi_1
X713 _0853_ a_q_14_ b_q_14_ _0409_ _0852_ sky130_fd_sc_hd__o22ai_1
X714 _0854_ _0228_ _0418_ _0847_ _0851_ _0853_ sky130_fd_sc_hd__o2111ai_1
X715 _0855_ _0836_ _0837_ _0854_ sky130_fd_sc_hd__a21oi_1
X716 result_comb_14_ _0292_ _0501_ _0834_ _0855_ sky130_fd_sc_hd__o31ai_1
X717 _0856_ _0226_ _0227_ _0292_ sky130_fd_sc_hd__nor3_1
X718 _0857_ _0293_ _0500_ sky130_fd_sc_hd__nand2_1
X719 _0858_ _0226_ _0228_ _0836_ sky130_fd_sc_hd__nand3_1
X720 _0859_ _0816_ _0835_ _0226_ _0229_ sky130_fd_sc_hd__a211o_1
X721 _0860_ _0226_ _0228_ sky130_fd_sc_hd__nor2_1
X722 _0861_ _0497_ _0860_ sky130_fd_sc_hd__nor2_1
X723 _0862_ b_q_3_ _0692_ sky130_fd_sc_hd__nand2_1
X724 _0863_ _0081_ _0688_ _0342_ sky130_fd_sc_hd__a21oi_1
X725 _0864_ b_q_0_ a_q_14_ _0483_ sky130_fd_sc_hd__a21oi_1
X726 _0865_ b_q_1_ _0864_ sky130_fd_sc_hd__nor2_1
X727 _0866_ b_q_1_ _0818_ _0865_ sky130_fd_sc_hd__a21oi_1
X728 _0867_ _0786_ _0866_ _0070_ sky130_fd_sc_hd__mux2i_1
X729 _0868_ b_q_3_ _0706_ sky130_fd_sc_hd__nand2_1
X730 _0869_ b_q_3_ _0867_ _0868_ sky130_fd_sc_hd__o21ai_0
X731 _0870_ b_q_4_ _0694_ _0699_ sky130_fd_sc_hd__nand3_1
X732 _0871_ b_q_4_ _0696_ sky130_fd_sc_hd__nand2_1
X733 _0872_ _0226_ _0413_ _0418_ _0225_ sky130_fd_sc_hd__o22ai_1
X734 _0873_ _0224_ _0409_ _0872_ sky130_fd_sc_hd__a21oi_1
X735 _0874_ _0870_ _0871_ _0873_ sky130_fd_sc_hd__nand3_1
X736 _0875_ _0862_ _0863_ _0874_ sky130_fd_sc_hd__a21oi_1
X737 _0876_ _0423_ _0869_ _0875_ sky130_fd_sc_hd__o21ai_0
X738 _0877_ _0858_ _0859_ _0861_ _0876_ sky130_fd_sc_hd__a31oi_1
X739 result_comb_15_ _0856_ _0857_ _0877_ sky130_fd_sc_hd__o21ai_0
X740 _0878_ _0221_ _0223_ _0293_ sky130_fd_sc_hd__nand3_1
X741 _0879_ _0295_ _0500_ _0878_ sky130_fd_sc_hd__nand3_1
X742 _0880_ a_q_15_ b_q_15_ _0860_ sky130_fd_sc_hd__a21oi_1
X743 _0881_ _0222_ _0859_ _0880_ sky130_fd_sc_hd__nand3_1
X744 _0882_ _0859_ _0880_ _0222_ sky130_fd_sc_hd__a21oi_1
X745 _0883_ _0496_ _0881_ sky130_fd_sc_hd__nand2_1
X746 _0884_ _0341_ _0696_ sky130_fd_sc_hd__nor2_1
X747 _0885_ _0102_ _0407_ _0884_ sky130_fd_sc_hd__a21oi_1
X748 _0886_ _0219_ _0412_ _0409_ sky130_fd_sc_hd__a21oi_1
X749 _0887_ _0219_ _0418_ _0886_ _0220_ sky130_fd_sc_hd__o22ai_1
X750 _0888_ _0367_ _0375_ sky130_fd_sc_hd__nand2_1
X751 _0889_ b_q_1_ _0888_ sky130_fd_sc_hd__nor2_1
X752 _0890_ b_q_1_ _0838_ _0889_ sky130_fd_sc_hd__a21oi_1
X753 _0891_ _0805_ _0890_ _0070_ sky130_fd_sc_hd__mux2i_1
X754 _0892_ b_q_3_ _0720_ b_q_4_ sky130_fd_sc_hd__a21oi_1
X755 _0893_ b_q_3_ _0891_ _0892_ sky130_fd_sc_hd__o21ai_0
X756 _0894_ _0102_ _0419_ _0420_ _0893_ sky130_fd_sc_hd__o211a_1
X757 _0895_ _0885_ _0887_ _0894_ sky130_fd_sc_hd__nor3_1
X758 result_comb_16_ _0882_ _0883_ _0895_ _0879_ sky130_fd_sc_hd__o211ai_1
X759 _0896_ _0217_ _0295_ sky130_fd_sc_hd__nand2_1
X760 _0897_ _0218_ _0299_ _0501_ sky130_fd_sc_hd__a21oi_1
X761 _0898_ _0299_ _0896_ _0897_ _0296_ sky130_fd_sc_hd__o211ai_1
X762 _0899_ _0217_ _0882_ sky130_fd_sc_hd__nor2_1
X763 _0900_ _0219_ _0899_ sky130_fd_sc_hd__nand2_1
X764 _0901_ _0859_ _0880_ _0218_ _0222_ sky130_fd_sc_hd__a211o_1
X765 _0902_ _0218_ _0219_ sky130_fd_sc_hd__nor2_1
X766 _0903_ _0218_ _0219_ _0496_ _0900_ _0901_ sky130_fd_sc_hd__o2111ai_1
X767 _0904_ _0427_ _0484_ sky130_fd_sc_hd__nand2_1
X768 _0905_ b_q_1_ _0904_ sky130_fd_sc_hd__nor2_1
X769 _0906_ b_q_1_ _0864_ _0905_ sky130_fd_sc_hd__a21oi_1
X770 _0907_ b_q_2_ _0906_ sky130_fd_sc_hd__nor2_1
X771 _0908_ b_q_2_ _0820_ _0907_ sky130_fd_sc_hd__a21oi_1
X772 _0909_ b_q_3_ _0747_ _0421_ sky130_fd_sc_hd__a21oi_1
X773 _0910_ b_q_3_ _0908_ _0909_ sky130_fd_sc_hd__o21ai_0
X774 _0911_ _0459_ _0910_ b_q_4_ sky130_fd_sc_hd__a21oi_1
X775 _0912_ a_q_17_ b_q_17_ _0417_ sky130_fd_sc_hd__nand3_1
X776 _0913_ a_q_17_ b_q_17_ _0409_ sky130_fd_sc_hd__o21ai_0
X777 _0914_ _0218_ _0413_ _0871_ _0912_ _0913_ sky130_fd_sc_hd__o2111ai_1
X778 _0915_ _0102_ _0421_ sky130_fd_sc_hd__nor2_1
X779 _0916_ b_q_4_ _0420_ sky130_fd_sc_hd__nand2_1
X780 _0917_ _0081_ _0493_ _0915_ _0914_ _0911_ sky130_fd_sc_hd__a311oi_1
X781 result_comb_17_ _0898_ _0903_ _0917_ sky130_fd_sc_hd__nand3_1
X782 _0918_ _0214_ _0296_ _0300_ sky130_fd_sc_hd__nand3_1
X783 _0919_ _0296_ _0300_ _0214_ sky130_fd_sc_hd__a21oi_1
X784 _0920_ _0501_ _0919_ sky130_fd_sc_hd__nor2_1
X785 _0921_ a_q_17_ b_q_17_ _0902_ sky130_fd_sc_hd__a21oi_1
X786 _0922_ _0901_ _0921_ _0215_ sky130_fd_sc_hd__a21oi_1
X787 _0923_ _0215_ _0901_ _0921_ sky130_fd_sc_hd__nand3_1
X788 _0924_ _0497_ _0922_ _0923_ sky130_fd_sc_hd__nor3b_1
X789 _0925_ b_q_0_ a_q_17_ _0378_ sky130_fd_sc_hd__a21oi_1
X790 _0926_ b_q_1_ _0888_ sky130_fd_sc_hd__nand2_1
X791 _0927_ b_q_1_ _0925_ _0926_ sky130_fd_sc_hd__o21ai_0
X792 _0928_ _0840_ _0927_ _0070_ sky130_fd_sc_hd__mux2_1
X793 _0929_ b_q_3_ _0928_ _0420_ sky130_fd_sc_hd__o21ai_0
X794 _0930_ b_q_3_ _0763_ _0929_ sky130_fd_sc_hd__a21oi_1
X795 _0931_ _0522_ _0930_ _0102_ sky130_fd_sc_hd__o21ai_0
X796 _0932_ _0213_ _0410_ _0871_ sky130_fd_sc_hd__o21ai_0
X797 _0933_ _0214_ _0412_ _0417_ _0212_ _0932_ sky130_fd_sc_hd__a221oi_1
X798 _0934_ b_q_3_ _0541_ _0916_ _0931_ _0933_ sky130_fd_sc_hd__o311ai_0
X799 result_comb_18_ _0918_ _0920_ _0924_ _0934_ sky130_fd_sc_hd__a211o_1
X800 _0935_ _0303_ _0919_ _0211_ sky130_fd_sc_hd__o21ai_0
X801 _0936_ _0211_ _0303_ _0919_ sky130_fd_sc_hd__or3_1
X802 _0937_ _0500_ _0935_ _0936_ sky130_fd_sc_hd__nand3_1
X803 _0938_ _0212_ _0922_ sky130_fd_sc_hd__nor2_1
X804 _0939_ _0211_ _0938_ sky130_fd_sc_hd__xnor2_1
X805 _0940_ b_q_0_ a_q_18_ _0430_ sky130_fd_sc_hd__a21oi_1
X806 _0941_ b_q_1_ _0940_ sky130_fd_sc_hd__nor2_1
X807 _0942_ b_q_1_ _0904_ _0941_ sky130_fd_sc_hd__a21oi_1
X808 _0943_ _0866_ _0942_ _0070_ sky130_fd_sc_hd__mux2i_1
X809 _0944_ b_q_3_ _0788_ sky130_fd_sc_hd__nand2_1
X810 _0945_ b_q_3_ _0943_ _0944_ _0420_ sky130_fd_sc_hd__o211ai_1
X811 _0946_ _0565_ _0945_ b_q_4_ sky130_fd_sc_hd__a21oi_1
X812 _0947_ b_q_3_ _0582_ _0916_ sky130_fd_sc_hd__nor3_1
X813 _0948_ _0211_ _0413_ _0418_ _0210_ sky130_fd_sc_hd__o22ai_1
X814 _0949_ _0209_ _0410_ _0871_ sky130_fd_sc_hd__o21ai_0
X815 _0950_ _0946_ _0947_ _0948_ _0949_ sky130_fd_sc_hd__nor4_1
X816 result_comb_19_ _0497_ _0939_ _0950_ _0937_ sky130_fd_sc_hd__o211ai_1
X817 _0951_ _0208_ _0297_ _0305_ _0306_ _0500_ sky130_fd_sc_hd__o311ai_0
X818 _0952_ _0211_ _0922_ sky130_fd_sc_hd__nand2b_1
X819 _0953_ a_q_19_ b_q_19_ _0212_ sky130_fd_sc_hd__o21ai_0
X820 _0954_ _0208_ _0210_ _0952_ _0953_ sky130_fd_sc_hd__and4_1
X821 _0955_ _0210_ _0952_ _0953_ _0208_ sky130_fd_sc_hd__a31oi_1
X822 _0956_ b_q_0_ a_q_19_ _0382_ sky130_fd_sc_hd__a21oi_1
X823 _0957_ _0925_ _0956_ _0039_ sky130_fd_sc_hd__mux2_1
X824 _0958_ b_q_2_ _0890_ sky130_fd_sc_hd__nand2_1
X825 _0959_ b_q_2_ _0957_ _0958_ sky130_fd_sc_hd__o21ai_0
X826 _0960_ b_q_3_ _0807_ sky130_fd_sc_hd__nand2_1
X827 _0961_ b_q_3_ _0959_ _0960_ _0422_ sky130_fd_sc_hd__o211ai_1
X828 _0962_ a_q_20_ b_q_20_ _0417_ sky130_fd_sc_hd__nand3_1
X829 _0963_ a_q_20_ b_q_20_ _0409_ sky130_fd_sc_hd__o21ai_0
X830 _0964_ _0208_ _0413_ _0962_ _0963_ sky130_fd_sc_hd__o211ai_1
X831 _0965_ b_q_4_ _0624_ _0964_ sky130_fd_sc_hd__a21oi_1
X832 _0966_ _0871_ _0961_ _0965_ sky130_fd_sc_hd__nand3_1
X833 _0967_ _0102_ _0603_ _0966_ sky130_fd_sc_hd__a21oi_1
X834 result_comb_20_ _0497_ _0954_ _0955_ _0967_ _0951_ sky130_fd_sc_hd__o311ai_0
X835 _0968_ _0206_ _0306_ _0308_ sky130_fd_sc_hd__nand3_1
X836 _0969_ _0206_ _0308_ _0500_ _0968_ _0307_ sky130_fd_sc_hd__o2111ai_1
X837 _0970_ _0210_ _0952_ _0953_ _0208_ _0207_ sky130_fd_sc_hd__a311oi_1
X838 _0971_ a_q_20_ b_q_20_ _0206_ _0955_ sky130_fd_sc_hd__a211oi_1
X839 _0972_ a_q_20_ b_q_20_ _0206_ sky130_fd_sc_hd__nand3_1
X840 _0973_ _0496_ _0972_ sky130_fd_sc_hd__nand2_1
X841 _0974_ a_q_21_ a_q_20_ b_q_0_ sky130_fd_sc_hd__mux2_1
X842 _0975_ b_q_1_ _0940_ sky130_fd_sc_hd__nand2_1
X843 _0976_ b_q_1_ _0974_ _0975_ sky130_fd_sc_hd__o21ai_0
X844 _0977_ b_q_2_ _0976_ sky130_fd_sc_hd__nor2_1
X845 _0978_ b_q_2_ _0906_ _0977_ sky130_fd_sc_hd__a21oi_1
X846 _0979_ _0081_ _0978_ sky130_fd_sc_hd__and2_0
X847 _0980_ b_q_3_ _0822_ _0979_ _0423_ sky130_fd_sc_hd__a211oi_1
X848 _0981_ b_q_3_ _0650_ _0916_ sky130_fd_sc_hd__nor3_1
X849 _0982_ a_q_21_ b_q_21_ _0409_ sky130_fd_sc_hd__o21ai_0
X850 _0983_ _0205_ _0418_ _0982_ sky130_fd_sc_hd__o21ai_0
X851 _0984_ _0980_ _0981_ _0983_ sky130_fd_sc_hd__nor3_1
X852 _0985_ _0207_ _0413_ _0871_ _0984_ sky130_fd_sc_hd__o211ai_1
X853 _0986_ _0102_ _0641_ _0985_ sky130_fd_sc_hd__a21oi_1
X854 result_comb_21_ _0970_ _0971_ _0973_ _0986_ _0969_ sky130_fd_sc_hd__o311ai_0
X855 _0987_ _0204_ _0311_ sky130_fd_sc_hd__xnor2_1
X856 _0988_ _0205_ _0972_ sky130_fd_sc_hd__nand2_1
X857 _0989_ _0970_ _0988_ _0203_ sky130_fd_sc_hd__o21ai_0
X858 _0990_ _0203_ _0970_ _0988_ sky130_fd_sc_hd__or3_1
X859 _0991_ _0383_ _0386_ sky130_fd_sc_hd__nand2_1
X860 _0992_ b_q_1_ _0956_ sky130_fd_sc_hd__nand2_1
X861 _0993_ b_q_1_ _0991_ _0992_ sky130_fd_sc_hd__o21ai_0
X862 _0994_ b_q_2_ _0927_ sky130_fd_sc_hd__nand2_1
X863 _0995_ b_q_2_ _0993_ _0994_ sky130_fd_sc_hd__o21ai_0
X864 _0996_ _0081_ _0842_ sky130_fd_sc_hd__nor2_1
X865 _0997_ b_q_3_ _0995_ _0420_ sky130_fd_sc_hd__o21ai_0
X866 _0998_ _0996_ _0997_ sky130_fd_sc_hd__nor2_1
X867 _0999_ _0666_ _0998_ _0102_ sky130_fd_sc_hd__o21ai_0
X868 _1000_ _0679_ _0916_ sky130_fd_sc_hd__nor2_1
X869 _1001_ _0202_ _0418_ sky130_fd_sc_hd__nor2_1
X870 _1002_ _0203_ _0412_ _1001_ sky130_fd_sc_hd__a21oi_1
X871 _1003_ a_q_22_ b_q_22_ _0409_ sky130_fd_sc_hd__o21ai_0
X872 _1004_ _0871_ _0999_ _1002_ _1003_ sky130_fd_sc_hd__nand4_1
X873 _1005_ _0496_ _0989_ _0990_ _1000_ _1004_ sky130_fd_sc_hd__a311oi_1
X874 result_comb_22_ _0501_ _0987_ _1005_ sky130_fd_sc_hd__o21ai_0
X875 _1006_ _0204_ _0311_ _0200_ sky130_fd_sc_hd__a21bo_1
X876 _1007_ _0199_ _1006_ sky130_fd_sc_hd__xor2_1
X877 _1008_ _0202_ _0989_ sky130_fd_sc_hd__nand2_1
X878 _1009_ _0199_ _1008_ sky130_fd_sc_hd__xor2_1
X879 _1010_ b_q_3_ _0867_ sky130_fd_sc_hd__nand2_1
X880 _1011_ _0434_ _0436_ b_q_1_ sky130_fd_sc_hd__a21oi_1
X881 _1012_ b_q_1_ _0974_ _1011_ sky130_fd_sc_hd__a21oi_1
X882 _1013_ _0942_ _1012_ _0070_ sky130_fd_sc_hd__mux2i_1
X883 _1014_ _0081_ _1013_ sky130_fd_sc_hd__nand2_1
X884 _1015_ _1010_ _1014_ _0421_ sky130_fd_sc_hd__a21oi_1
X885 _1016_ _0701_ _1015_ _0102_ sky130_fd_sc_hd__o21ai_0
X886 _1017_ b_q_3_ _0706_ _0916_ sky130_fd_sc_hd__nor3_1
X887 _1018_ a_q_23_ b_q_23_ _0409_ sky130_fd_sc_hd__o21ai_0
X888 _1019_ _0198_ _0418_ sky130_fd_sc_hd__nor2_1
X889 _1020_ _0199_ _0412_ _1019_ sky130_fd_sc_hd__a21oi_1
X890 _1021_ _0871_ _1016_ _1018_ _1020_ sky130_fd_sc_hd__nand4_1
X891 _1022_ _0496_ _1009_ _1017_ _1021_ sky130_fd_sc_hd__a211oi_1
X892 result_comb_23_ _0501_ _1007_ _1022_ sky130_fd_sc_hd__o21ai_0
X893 _1023_ _0196_ _0201_ _0312_ sky130_fd_sc_hd__or3_1
X894 _1024_ _0970_ _0988_ _0199_ _0203_ sky130_fd_sc_hd__o211ai_1
X895 _1025_ a_q_23_ b_q_23_ b_q_22_ a_q_22_ sky130_fd_sc_hd__o211ai_1
X896 _0001_ _0198_ _1024_ _1025_ sky130_fd_sc_hd__nand3_1
X897 _0002_ _0198_ _1024_ _1025_ _0196_ sky130_fd_sc_hd__a31oi_1
X898 _0003_ _0195_ _0001_ _0496_ sky130_fd_sc_hd__o21ai_0
X899 _0004_ b_q_0_ a_q_23_ _0391_ sky130_fd_sc_hd__a21oi_1
X900 _0005_ b_q_1_ _0991_ sky130_fd_sc_hd__nand2_1
X901 _0006_ b_q_1_ _0004_ _0005_ sky130_fd_sc_hd__o21ai_0
X902 _0007_ _0070_ _0957_ _0081_ sky130_fd_sc_hd__o21ai_0
X903 _0008_ _0070_ _0006_ _0007_ sky130_fd_sc_hd__a21oi_1
X904 _0009_ _0423_ _0722_ _0891_ b_q_3_ _0008_ sky130_fd_sc_hd__a221oi_1
X905 _0010_ _0196_ _0413_ _0418_ _0193_ sky130_fd_sc_hd__o22ai_1
X906 _0011_ _0194_ _0410_ _0871_ sky130_fd_sc_hd__o21ai_0
X907 _0012_ _0341_ _0727_ _0009_ _0010_ _0011_ sky130_fd_sc_hd__a2111oi_0
X908 _0013_ _0102_ _0722_ _0012_ sky130_fd_sc_hd__o21ai_0
X909 _0014_ _0316_ _0500_ _1023_ _0013_ sky130_fd_sc_hd__a31oi_1
X910 result_comb_24_ _0002_ _0003_ _0014_ sky130_fd_sc_hd__o21ai_0
X911 _0015_ _0191_ _0316_ _0318_ sky130_fd_sc_hd__nand3_1
X912 _0016_ _0319_ _0501_ sky130_fd_sc_hd__nor2_1
X913 _0017_ _0317_ _0015_ _0016_ sky130_fd_sc_hd__nand3_1
X914 _0018_ _0198_ _1024_ _1025_ _0196_ _0192_ sky130_fd_sc_hd__a311oi_1
X915 _0019_ _0192_ _0193_ sky130_fd_sc_hd__nand2_1
X916 _0020_ _0192_ _0193_ sky130_fd_sc_hd__nor2_1
X917 _0021_ _0497_ _0018_ _0020_ sky130_fd_sc_hd__nor3_1
X918 _0022_ _0002_ _0019_ _0021_ sky130_fd_sc_hd__o21ai_0
X919 _0023_ b_q_0_ a_q_24_ _0443_ sky130_fd_sc_hd__a21o_1
X920 _0024_ _0434_ _0436_ _0039_ sky130_fd_sc_hd__a21oi_1
X921 _0025_ _0039_ _0023_ _0024_ sky130_fd_sc_hd__a21o_1
X922 _0026_ b_q_2_ _0025_ _0081_ sky130_fd_sc_hd__o21ai_0
X923 _0027_ b_q_2_ _0976_ _0026_ sky130_fd_sc_hd__a21oi_1
X924 _0028_ b_q_3_ _0908_ _0027_ sky130_fd_sc_hd__a21oi_1
X925 _0029_ _0191_ _0412_ _0417_ _0189_ sky130_fd_sc_hd__a22o_1
X926 _0030_ _0190_ _0410_ _0871_ sky130_fd_sc_hd__o21ai_0
X927 _0031_ _0749_ _0915_ _0029_ _0030_ sky130_fd_sc_hd__a211oi_1
X928 _0032_ _0423_ _0028_ _0031_ sky130_fd_sc_hd__o21ai_0
X929 _0033_ _0102_ _0739_ _0032_ sky130_fd_sc_hd__a21oi_1
X930 result_comb_25_ _0017_ _0022_ _0033_ sky130_fd_sc_hd__nand3_1
X931 _0034_ _0186_ _0317_ _0320_ sky130_fd_sc_hd__nand3_1
X932 _0035_ _0317_ _0320_ _0186_ sky130_fd_sc_hd__a21oi_1
X933 _0036_ _0501_ _0035_ sky130_fd_sc_hd__nor2_1
X934 _0037_ _0034_ _0036_ sky130_fd_sc_hd__nand2_1
X935 _0038_ _0189_ _0018_ _0020_ sky130_fd_sc_hd__nor3_1
X936 _0040_ _0187_ _0038_ sky130_fd_sc_hd__xnor2_1
X937 _0041_ b_q_0_ a_q_25_ _0393_ sky130_fd_sc_hd__a21oi_1
X938 _0042_ _0004_ _0041_ _0039_ sky130_fd_sc_hd__mux2i_1
X939 _0043_ b_q_2_ _0042_ sky130_fd_sc_hd__nor2_1
X940 _0044_ b_q_2_ _0993_ _0043_ b_q_3_ sky130_fd_sc_hd__a211oi_1
X941 _0045_ b_q_3_ _0928_ _0044_ sky130_fd_sc_hd__a21oi_1
X942 _0046_ _0186_ _0412_ _0417_ _0184_ sky130_fd_sc_hd__a22oi_1
X943 _0047_ _0185_ _0410_ _0871_ _0046_ sky130_fd_sc_hd__o211ai_1
X944 _0048_ _0765_ _0915_ _0047_ sky130_fd_sc_hd__a21oi_1
X945 _0049_ _0423_ _0045_ _0048_ sky130_fd_sc_hd__o21ai_0
X946 _0051_ _0102_ _0758_ _0049_ sky130_fd_sc_hd__a21oi_1
X947 result_comb_26_ _0497_ _0040_ _0051_ _0037_ sky130_fd_sc_hd__o211ai_1
X948 _0052_ _0321_ _0035_ _0183_ sky130_fd_sc_hd__o21ai_0
X949 _0053_ _0183_ _0321_ _0035_ sky130_fd_sc_hd__or3_1
X950 _0054_ _0187_ _0038_ _0184_ sky130_fd_sc_hd__o21bai_1
X951 _0055_ _0182_ _0054_ sky130_fd_sc_hd__xnor2_1
X952 _0056_ _0698_ _0779_ _0780_ b_q_4_ sky130_fd_sc_hd__a31oi_1
X953 _0057_ a_q_27_ a_q_26_ b_q_0_ sky130_fd_sc_hd__mux2i_1
X954 _0058_ b_q_1_ _0057_ sky130_fd_sc_hd__nor2_1
X955 _0059_ b_q_1_ _0023_ _0058_ sky130_fd_sc_hd__a21oi_1
X956 _0061_ _1012_ _0059_ _0070_ sky130_fd_sc_hd__mux2_1
X957 _0062_ b_q_3_ _0061_ sky130_fd_sc_hd__nor2_1
X958 _0063_ b_q_3_ _0943_ _0062_ sky130_fd_sc_hd__a21oi_1
X959 _0064_ _0183_ _0413_ _0418_ _0180_ sky130_fd_sc_hd__o22ai_1
X960 _0065_ _0181_ _0410_ _0871_ sky130_fd_sc_hd__o21ai_0
X961 _0066_ _0064_ _0065_ sky130_fd_sc_hd__nor2_1
X962 _0067_ _0423_ _0063_ _0066_ sky130_fd_sc_hd__o21ai_0
X963 _0068_ _0789_ _0915_ _0056_ _0067_ sky130_fd_sc_hd__a211o_1
X964 _0069_ _0500_ _0052_ _0053_ _0068_ sky130_fd_sc_hd__a31oi_1
X965 result_comb_27_ _0497_ _0055_ _0069_ sky130_fd_sc_hd__o21ai_0
X966 _0071_ _0178_ _0324_ _0501_ sky130_fd_sc_hd__a21oi_1
X967 _0072_ _0325_ _0071_ sky130_fd_sc_hd__nand2_1
X968 _0073_ _0189_ _0018_ _0020_ _0186_ _0182_ sky130_fd_sc_hd__o311ai_0
X969 _0074_ a_q_27_ b_q_27_ _0184_ sky130_fd_sc_hd__o21ai_0
X970 _0075_ _0180_ _0073_ _0074_ sky130_fd_sc_hd__nand3_1
X971 _0076_ _0178_ _0075_ sky130_fd_sc_hd__xnor2_1
X972 _0077_ _0809_ _0916_ sky130_fd_sc_hd__nor2_1
X973 _0078_ a_q_28_ b_q_28_ _0413_ sky130_fd_sc_hd__a21oi_1
X974 _0079_ a_q_28_ b_q_28_ _0409_ _0078_ sky130_fd_sc_hd__o22ai_1
X975 _0080_ _0081_ _0959_ sky130_fd_sc_hd__lpflow_inputiso1p_1
X976 _0082_ _0394_ _0397_ sky130_fd_sc_hd__nand2_1
X977 _0083_ b_q_1_ _0041_ sky130_fd_sc_hd__nand2_1
X978 _0084_ b_q_1_ _0082_ _0083_ sky130_fd_sc_hd__o21ai_0
X979 _0085_ b_q_2_ _0006_ b_q_3_ sky130_fd_sc_hd__a21oi_1
X980 _0086_ b_q_2_ _0084_ _0085_ sky130_fd_sc_hd__o21ai_0
X981 _0087_ _0422_ _0080_ _0086_ _0077_ sky130_fd_sc_hd__a31oi_1
X982 _0088_ _0177_ _0418_ _0871_ _0079_ _0087_ sky130_fd_sc_hd__o2111ai_1
X983 _0089_ _0102_ _0798_ _0088_ sky130_fd_sc_hd__a21oi_1
X984 result_comb_28_ _0497_ _0076_ _0089_ _0072_ sky130_fd_sc_hd__o211ai_1
X985 _0090_ _0174_ _0176_ _0325_ _0501_ sky130_fd_sc_hd__a31oi_1
X986 _0092_ _0180_ _0073_ _0074_ _0179_ _0175_ sky130_fd_sc_hd__a311o_1
X987 _0093_ _0175_ _0177_ sky130_fd_sc_hd__nand2_1
X988 _0094_ _0178_ _0075_ _0093_ sky130_fd_sc_hd__a21oi_1
X989 _0095_ a_q_28_ b_q_28_ _0174_ sky130_fd_sc_hd__nand3_1
X990 _0096_ _0496_ _0092_ _0095_ sky130_fd_sc_hd__nand3_1
X991 _0097_ _0173_ _0410_ _0871_ sky130_fd_sc_hd__o21ai_0
X992 _0098_ _0175_ _0413_ _0418_ _0172_ sky130_fd_sc_hd__o22ai_1
X993 _0099_ b_q_1_ _0057_ sky130_fd_sc_hd__and2_0
X994 _0100_ b_q_0_ a_q_28_ _0448_ sky130_fd_sc_hd__a21oi_1
X995 _0101_ _0039_ _0100_ _0099_ b_q_2_ sky130_fd_sc_hd__a211oi_1
X996 _0103_ b_q_2_ _0025_ _0101_ b_q_3_ sky130_fd_sc_hd__a211oi_1
X997 _0104_ b_q_3_ _0978_ _0103_ _0423_ sky130_fd_sc_hd__a211oi_1
X998 _0105_ _0102_ _0830_ _0097_ _0098_ _0104_ sky130_fd_sc_hd__a2111oi_0
X999 _0106_ _0823_ _0916_ _0105_ sky130_fd_sc_hd__o21ai_0
X1000 _0107_ _0327_ _0090_ _0106_ sky130_fd_sc_hd__a21oi_1
X1001 result_comb_29_ _0094_ _0096_ _0107_ sky130_fd_sc_hd__o21ai_0
X1002 _0108_ _0170_ _0328_ _0501_ sky130_fd_sc_hd__a21o_1
X1003 _0109_ _0172_ _0092_ _0095_ sky130_fd_sc_hd__nand3_1
X1004 _0110_ _0170_ _0109_ sky130_fd_sc_hd__xor2_1
X1005 _0111_ b_q_0_ a_q_29_ _0400_ sky130_fd_sc_hd__a21oi_1
X1006 _0113_ b_q_1_ _0111_ sky130_fd_sc_hd__nor2_1
X1007 _0114_ b_q_1_ _0082_ _0113_ sky130_fd_sc_hd__a21oi_1
X1008 _0115_ b_q_2_ _0042_ sky130_fd_sc_hd__nand2_1
X1009 _0116_ b_q_2_ _0114_ _0115_ _0081_ sky130_fd_sc_hd__o211ai_1
X1010 _0117_ _0081_ _0995_ _0116_ _0422_ sky130_fd_sc_hd__o211ai_1
X1011 _0118_ _0169_ _0410_ _0418_ _0168_ sky130_fd_sc_hd__o22ai_1
X1012 _0119_ b_q_4_ _0844_ _0118_ sky130_fd_sc_hd__a21oi_1
X1013 _0120_ _0170_ _0412_ _0850_ _0102_ sky130_fd_sc_hd__a22oi_1
X1014 _0121_ _0871_ _0117_ _0119_ _0120_ sky130_fd_sc_hd__nand4_1
X1015 _0122_ _0496_ _0110_ _0121_ sky130_fd_sc_hd__a21oi_1
X1016 result_comb_30_ _0329_ _0108_ _0122_ sky130_fd_sc_hd__o21ai_0
X1017 _0124_ _0153_ _0330_ sky130_fd_sc_hd__xor2_1
X1018 _0125_ _0170_ _0109_ _0168_ sky130_fd_sc_hd__a21boi_0
X1019 _0126_ _0153_ _0125_ sky130_fd_sc_hd__xnor2_1
X1020 _0127_ b_q_0_ a_q_30_ _0451_ b_q_1_ sky130_fd_sc_hd__a211oi_1
X1021 _0128_ b_q_1_ _0100_ _0127_ sky130_fd_sc_hd__a21o_1
X1022 _0129_ _0942_ _1012_ _0059_ _0128_ _0070_ _0081_ sky130_fd_sc_hd__mux4_2
X1023 _0130_ _0133_ _0418_ sky130_fd_sc_hd__nor2_1
X1024 _0131_ _0153_ _0412_ _0130_ sky130_fd_sc_hd__a21oi_1
X1025 _0132_ _0143_ _0410_ _0869_ _0916_ _0131_ sky130_fd_sc_hd__o221ai_1
X1026 _0134_ _0102_ _0694_ _0699_ _0132_ _0696_ sky130_fd_sc_hd__a311oi_1
X1027 _0135_ _0423_ _0129_ _0134_ sky130_fd_sc_hd__o21ai_0
X1028 _0136_ _0496_ _0126_ _0135_ sky130_fd_sc_hd__a21oi_1
X1029 result_comb_31_ _0501_ _0124_ _0136_ sky130_fd_sc_hd__o21ai_0
X1030 _0137_ result_comb_1_ result_comb_2_ result_comb_3_ result_comb_4_ sky130_fd_sc_hd__or4_1
X1031 _0138_ result_comb_5_ result_comb_6_ _0137_ sky130_fd_sc_hd__or3_1
X1032 _0139_ result_comb_8_ result_comb_9_ sky130_fd_sc_hd__nor2_1
X1033 _0140_ result_comb_7_ result_comb_10_ _0138_ _0139_ sky130_fd_sc_hd__or4b_1
X1034 _0141_ result_comb_11_ result_comb_12_ result_comb_13_ _0140_ sky130_fd_sc_hd__or4_1
X1035 _0142_ result_comb_14_ result_comb_15_ result_comb_16_ _0141_ sky130_fd_sc_hd__nor4_1
X1036 _0144_ result_comb_17_ result_comb_18_ result_comb_19_ _0142_ sky130_fd_sc_hd__or4b_1
X1037 _0145_ result_comb_21_ result_comb_22_ sky130_fd_sc_hd__nor2_1
X1038 _0146_ result_comb_20_ result_comb_23_ _0144_ _0145_ sky130_fd_sc_hd__or4b_1
X1039 _0147_ result_comb_24_ result_comb_25_ result_comb_26_ _0146_ sky130_fd_sc_hd__or4_1
X1040 _0148_ result_comb_27_ result_comb_28_ result_comb_29_ _0147_ sky130_fd_sc_hd__or4_1
X1041 _0000_ result_comb_0_ result_comb_30_ result_comb_31_ _0148_ sky130_fd_sc_hd__nor4_1
X1042 _0149_ _0124_ a_q_31_ sky130_fd_sc_hd__lpflow_isobufsrc_1
X1043 _0150_ a_q_31_ _0330_ _0500_ _0153_ sky130_fd_sc_hd__o211ai_1
X1044 _0151_ _0133_ _0125_ sky130_fd_sc_hd__and2_0
X1045 _0152_ _0143_ _0125_ _0496_ sky130_fd_sc_hd__o21ai_0
X1046 overflow_comb _0149_ _0150_ _0151_ _0152_ sky130_fd_sc_hd__o22ai_1
X1047 _0154_ _0153_ _0170_ sky130_fd_sc_hd__nand2_1
X1048 _0155_ _0092_ _0154_ sky130_fd_sc_hd__nor2_1
X1049 _0156_ _0172_ _0095_ _0154_ sky130_fd_sc_hd__a21oi_1
X1050 _0157_ _0143_ _0168_ _0133_ sky130_fd_sc_hd__o21ai_0
X1051 _0158_ _0155_ _0156_ _0157_ sky130_fd_sc_hd__nor3_1
X1052 _0159_ _0153_ _0170_ sky130_fd_sc_hd__nor2_1
X1053 _0160_ _0153_ _0170_ _0174_ _0325_ sky130_fd_sc_hd__nor4_1
X1054 _0161_ _0174_ _0176_ _0171_ sky130_fd_sc_hd__o21ai_0
X1055 _0162_ _0159_ _0161_ sky130_fd_sc_hd__nand2_1
X1056 _0164_ _0153_ _0167_ sky130_fd_sc_hd__nand2b_1
X1057 _0165_ _0163_ _0162_ _0164_ sky130_fd_sc_hd__nand3_1
X1058 _0166_ _0160_ _0165_ _0500_ sky130_fd_sc_hd__o21ai_0
X1059 carry_comb _0497_ _0158_ _0166_ sky130_fd_sc_hd__o21ai_0
X1060 result_o_0_ clk result_comb_0_ rst_n sky130_fd_sc_hd__dfrtp_1
X1061 result_o_1_ clk result_comb_1_ rst_n sky130_fd_sc_hd__dfrtp_1
X1062 result_o_2_ clk result_comb_2_ rst_n sky130_fd_sc_hd__dfrtp_1
X1063 result_o_3_ clk result_comb_3_ rst_n sky130_fd_sc_hd__dfrtp_1
X1064 result_o_4_ clk result_comb_4_ rst_n sky130_fd_sc_hd__dfrtp_1
X1065 result_o_5_ clk result_comb_5_ rst_n sky130_fd_sc_hd__dfrtp_1
X1066 result_o_6_ clk result_comb_6_ rst_n sky130_fd_sc_hd__dfrtp_1
X1067 result_o_7_ clk result_comb_7_ rst_n sky130_fd_sc_hd__dfrtp_1
X1068 result_o_8_ clk result_comb_8_ rst_n sky130_fd_sc_hd__dfrtp_1
X1069 result_o_9_ clk result_comb_9_ rst_n sky130_fd_sc_hd__dfrtp_1
X1070 result_o_10_ clk result_comb_10_ rst_n sky130_fd_sc_hd__dfrtp_1
X1071 result_o_11_ clk result_comb_11_ rst_n sky130_fd_sc_hd__dfrtp_1
X1072 result_o_12_ clk result_comb_12_ rst_n sky130_fd_sc_hd__dfrtp_1
X1073 result_o_13_ clk result_comb_13_ rst_n sky130_fd_sc_hd__dfrtp_1
X1074 result_o_14_ clk result_comb_14_ rst_n sky130_fd_sc_hd__dfrtp_1
X1075 result_o_15_ clk result_comb_15_ rst_n sky130_fd_sc_hd__dfrtp_1
X1076 result_o_16_ clk result_comb_16_ rst_n sky130_fd_sc_hd__dfrtp_1
X1077 result_o_17_ clk result_comb_17_ rst_n sky130_fd_sc_hd__dfrtp_1
X1078 result_o_18_ clk result_comb_18_ rst_n sky130_fd_sc_hd__dfrtp_1
X1079 result_o_19_ clk result_comb_19_ rst_n sky130_fd_sc_hd__dfrtp_1
X1080 result_o_20_ clk result_comb_20_ rst_n sky130_fd_sc_hd__dfrtp_1
X1081 result_o_21_ clk result_comb_21_ rst_n sky130_fd_sc_hd__dfrtp_1
X1082 result_o_22_ clk result_comb_22_ rst_n sky130_fd_sc_hd__dfrtp_1
X1083 result_o_23_ clk result_comb_23_ rst_n sky130_fd_sc_hd__dfrtp_1
X1084 result_o_24_ clk result_comb_24_ rst_n sky130_fd_sc_hd__dfrtp_1
X1085 result_o_25_ clk result_comb_25_ rst_n sky130_fd_sc_hd__dfrtp_1
X1086 result_o_26_ clk result_comb_26_ rst_n sky130_fd_sc_hd__dfrtp_1
X1087 result_o_27_ clk result_comb_27_ rst_n sky130_fd_sc_hd__dfrtp_1
X1088 result_o_28_ clk result_comb_28_ rst_n sky130_fd_sc_hd__dfrtp_1
X1089 result_o_29_ clk result_comb_29_ rst_n sky130_fd_sc_hd__dfrtp_1
X1090 result_o_30_ clk result_comb_30_ rst_n sky130_fd_sc_hd__dfrtp_1
X1091 result_o_31_ clk result_comb_31_ rst_n sky130_fd_sc_hd__dfrtp_1
X1092 valid_o clk valid_q rst_n sky130_fd_sc_hd__dfrtp_1
X1093 carry_o clk carry_comb rst_n sky130_fd_sc_hd__dfrtp_1
X1094 overflow_o clk overflow_comb rst_n sky130_fd_sc_hd__dfrtp_1
X1095 zero_o clk _0000_ rst_n sky130_fd_sc_hd__dfrtp_1
X1096 a_q_0_ clk operand_a_0_ rst_n sky130_fd_sc_hd__dfrtp_1
X1097 a_q_1_ clk operand_a_1_ rst_n sky130_fd_sc_hd__dfrtp_1
X1098 a_q_2_ clk operand_a_2_ rst_n sky130_fd_sc_hd__dfrtp_1
X1099 a_q_3_ clk operand_a_3_ rst_n sky130_fd_sc_hd__dfrtp_1
X1100 a_q_4_ clk operand_a_4_ rst_n sky130_fd_sc_hd__dfrtp_1
X1101 a_q_5_ clk operand_a_5_ rst_n sky130_fd_sc_hd__dfrtp_1
X1102 a_q_6_ clk operand_a_6_ rst_n sky130_fd_sc_hd__dfrtp_1
X1103 a_q_7_ clk operand_a_7_ rst_n sky130_fd_sc_hd__dfrtp_1
X1104 a_q_8_ clk operand_a_8_ rst_n sky130_fd_sc_hd__dfrtp_1
X1105 a_q_9_ clk operand_a_9_ rst_n sky130_fd_sc_hd__dfrtp_1
X1106 a_q_10_ clk operand_a_10_ rst_n sky130_fd_sc_hd__dfrtp_1
X1107 a_q_11_ clk operand_a_11_ rst_n sky130_fd_sc_hd__dfrtp_1
X1108 a_q_12_ clk operand_a_12_ rst_n sky130_fd_sc_hd__dfrtp_1
X1109 a_q_13_ clk operand_a_13_ rst_n sky130_fd_sc_hd__dfrtp_1
X1110 a_q_14_ clk operand_a_14_ rst_n sky130_fd_sc_hd__dfrtp_1
X1111 a_q_15_ clk operand_a_15_ rst_n sky130_fd_sc_hd__dfrtp_1
X1112 a_q_16_ clk operand_a_16_ rst_n sky130_fd_sc_hd__dfrtp_1
X1113 a_q_17_ clk operand_a_17_ rst_n sky130_fd_sc_hd__dfrtp_1
X1114 a_q_18_ clk operand_a_18_ rst_n sky130_fd_sc_hd__dfrtp_1
X1115 a_q_19_ clk operand_a_19_ rst_n sky130_fd_sc_hd__dfrtp_1
X1116 a_q_20_ clk operand_a_20_ rst_n sky130_fd_sc_hd__dfrtp_1
X1117 a_q_21_ clk operand_a_21_ rst_n sky130_fd_sc_hd__dfrtp_1
X1118 a_q_22_ clk operand_a_22_ rst_n sky130_fd_sc_hd__dfrtp_1
X1119 a_q_23_ clk operand_a_23_ rst_n sky130_fd_sc_hd__dfrtp_1
X1120 a_q_24_ clk operand_a_24_ rst_n sky130_fd_sc_hd__dfrtp_1
X1121 a_q_25_ clk operand_a_25_ rst_n sky130_fd_sc_hd__dfrtp_1
X1122 a_q_26_ clk operand_a_26_ rst_n sky130_fd_sc_hd__dfrtp_1
X1123 a_q_27_ clk operand_a_27_ rst_n sky130_fd_sc_hd__dfrtp_1
X1124 a_q_28_ clk operand_a_28_ rst_n sky130_fd_sc_hd__dfrtp_1
X1125 a_q_29_ clk operand_a_29_ rst_n sky130_fd_sc_hd__dfrtp_1
X1126 a_q_30_ clk operand_a_30_ rst_n sky130_fd_sc_hd__dfrtp_1
X1127 a_q_31_ clk operand_a_31_ rst_n sky130_fd_sc_hd__dfrtp_1
X1128 b_q_0_ clk operand_b_0_ rst_n sky130_fd_sc_hd__dfrtp_1
X1129 b_q_1_ clk operand_b_1_ rst_n sky130_fd_sc_hd__dfrtp_1
X1130 b_q_2_ clk operand_b_2_ rst_n sky130_fd_sc_hd__dfrtp_1
X1131 b_q_3_ clk operand_b_3_ rst_n sky130_fd_sc_hd__dfrtp_1
X1132 b_q_4_ clk operand_b_4_ rst_n sky130_fd_sc_hd__dfrtp_1
X1133 b_q_5_ clk operand_b_5_ rst_n sky130_fd_sc_hd__dfrtp_1
X1134 b_q_6_ clk operand_b_6_ rst_n sky130_fd_sc_hd__dfrtp_1
X1135 b_q_7_ clk operand_b_7_ rst_n sky130_fd_sc_hd__dfrtp_1
X1136 b_q_8_ clk operand_b_8_ rst_n sky130_fd_sc_hd__dfrtp_1
X1137 b_q_9_ clk operand_b_9_ rst_n sky130_fd_sc_hd__dfrtp_1
X1138 b_q_10_ clk operand_b_10_ rst_n sky130_fd_sc_hd__dfrtp_1
X1139 b_q_11_ clk operand_b_11_ rst_n sky130_fd_sc_hd__dfrtp_1
X1140 b_q_12_ clk operand_b_12_ rst_n sky130_fd_sc_hd__dfrtp_1
X1141 b_q_13_ clk operand_b_13_ rst_n sky130_fd_sc_hd__dfrtp_1
X1142 b_q_14_ clk operand_b_14_ rst_n sky130_fd_sc_hd__dfrtp_1
X1143 b_q_15_ clk operand_b_15_ rst_n sky130_fd_sc_hd__dfrtp_1
X1144 b_q_16_ clk operand_b_16_ rst_n sky130_fd_sc_hd__dfrtp_1
X1145 b_q_17_ clk operand_b_17_ rst_n sky130_fd_sc_hd__dfrtp_1
X1146 b_q_18_ clk operand_b_18_ rst_n sky130_fd_sc_hd__dfrtp_1
X1147 b_q_19_ clk operand_b_19_ rst_n sky130_fd_sc_hd__dfrtp_1
X1148 b_q_20_ clk operand_b_20_ rst_n sky130_fd_sc_hd__dfrtp_1
X1149 b_q_21_ clk operand_b_21_ rst_n sky130_fd_sc_hd__dfrtp_1
X1150 b_q_22_ clk operand_b_22_ rst_n sky130_fd_sc_hd__dfrtp_1
X1151 b_q_23_ clk operand_b_23_ rst_n sky130_fd_sc_hd__dfrtp_1
X1152 b_q_24_ clk operand_b_24_ rst_n sky130_fd_sc_hd__dfrtp_1
X1153 b_q_25_ clk operand_b_25_ rst_n sky130_fd_sc_hd__dfrtp_1
X1154 b_q_26_ clk operand_b_26_ rst_n sky130_fd_sc_hd__dfrtp_1
X1155 b_q_27_ clk operand_b_27_ rst_n sky130_fd_sc_hd__dfrtp_1
X1156 b_q_28_ clk operand_b_28_ rst_n sky130_fd_sc_hd__dfrtp_1
X1157 b_q_29_ clk operand_b_29_ rst_n sky130_fd_sc_hd__dfrtp_1
X1158 b_q_30_ clk operand_b_30_ rst_n sky130_fd_sc_hd__dfrtp_1
X1159 b_q_31_ clk operand_b_31_ rst_n sky130_fd_sc_hd__dfrtp_1
X1160 opcode_q_0_ clk opcode_0_ rst_n sky130_fd_sc_hd__dfrtp_1
X1161 opcode_q_1_ clk opcode_1_ rst_n sky130_fd_sc_hd__dfrtp_1
X1162 opcode_q_2_ clk opcode_2_ rst_n sky130_fd_sc_hd__dfrtp_1
X1163 opcode_q_3_ clk opcode_3_ rst_n sky130_fd_sc_hd__dfrtp_1
X1164 valid_q clk valid_i rst_n sky130_fd_sc_hd__dfrtp_1

.ends alu_32bit

************************
* end of SPICE netlist *
************************
